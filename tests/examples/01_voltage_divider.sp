* Voltage Divider
V1 vin 0 5
R1 vin vout 10k
R2 vout 0 10k
