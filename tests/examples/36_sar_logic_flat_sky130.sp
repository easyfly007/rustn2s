* SAR Logic, Flat Extracted Netlist, 684 Devices (SKY130) [n2s test case 36]
*
* === n2s test-case metadata ===
* Source:       myadc repo, sky130/layout/sar_logic/sar_logic_flat.spice
* Circuit type: Complete 8-bit SAR logic (bit registers + ring counter +
*               clock gating), flattened by magic extraction from layout
* Devices:      684 total -- all MOSFET X instances (sky130_fd_pr__nfet_01v8
*               and sky130_fd_pr__pfet_01v8_hvt)
* MOSFETs:      684
* Notes:        SCALE stress -- 7x larger than previous max (case 29, 92 dev).
*               Extraction-style node names contain `#` (a_2137_8527#) and
*               `.` (sky130_fd_sc_hd__nand2_1_3.B); devices carry ad/pd/as/ps
*               geometry params. Tests HAC, Sugiyama and A* at real scale.
* Added:        2026-07-03  (real-world test-set enrichment, batch 2)
* ===============================
* NGSPICE file created from sar_logic_flat.ext - technology: sky130A

.subckt sar_logic_flat outp outn sample comp_clk done bit7 bit7_b bit6 bit6_b bit5
+ bit5_b bit4 bit4_b bit3 bit3_b bit2 bit2_b bit1 bit1_b bit0 bit0_b vdd vss
X0 a_2137_8527# sky130_fd_sc_hd__nand2_1_3.B vss sky130_fd_sc_hd__nand2_1_59.VNB sky130_fd_pr__nfet_01v8 ad=0.08775 pd=0.92 as=0.169 ps=1.82 w=0.65 l=0.15
X1 vdd sky130_fd_sc_hd__nand2_1_2.B a_3981_3855# sky130_fd_sc_hd__nand2_1_28.VPB sky130_fd_pr__pfet_01v8_hvt ad=0.26 pd=2.52 as=0.105 ps=1.21 w=1 l=0.15
X2 sky130_fd_sc_hd__inv_1_122.A sky130_fd_sc_hd__inv_1_123.A vdd sky130_fd_sc_hd__nand2_1_44.VPB sky130_fd_pr__pfet_01v8_hvt ad=0.26 pd=2.52 as=0.26 ps=2.52 w=1 l=0.15
X3 a_4537_4175# sky130_fd_sc_hd__nand2_1_2.B vss sky130_fd_sc_hd__nand2_1_59.VNB sky130_fd_pr__nfet_01v8 ad=0.08775 pd=0.92 as=0.169 ps=1.82 w=0.65 l=0.15
X4 sky130_fd_sc_hd__inv_1_96.A sky130_fd_sc_hd__inv_1_97.A vdd sky130_fd_sc_hd__nand2_1_36.VPB sky130_fd_pr__pfet_01v8_hvt ad=0.26 pd=2.52 as=0.26 ps=2.52 w=1 l=0.15
X5 outn sky130_fd_sc_hd__nand2_1_2.A a_193_7439# sky130_fd_sc_hd__nand2_1_59.VNB sky130_fd_pr__nfet_01v8 ad=0.169 pd=1.82 as=0.10725 ps=0.98 w=0.65 l=0.15
X6 sky130_fd_sc_hd__inv_1_126.A sky130_fd_sc_hd__inv_1_127.A vss sky130_fd_sc_hd__nand2_1_59.VNB sky130_fd_pr__nfet_01v8 ad=0.169 pd=1.82 as=0.169 ps=1.82 w=0.65 l=0.15
X7 sky130_fd_sc_hd__nand2_1_41.B sky130_fd_sc_hd__nand2_1_2.B vdd sky130_fd_sc_hd__nand2_1_36.VPB sky130_fd_pr__pfet_01v8_hvt ad=0.26 pd=2.52 as=0.26 ps=2.52 w=1 l=0.15
X8 a_5365_4175# sky130_fd_sc_hd__nand2_1_28.B vss sky130_fd_sc_hd__nand2_1_59.VNB sky130_fd_pr__nfet_01v8 ad=0.08775 pd=0.92 as=0.169 ps=1.82 w=0.65 l=0.15
X9 sky130_fd_sc_hd__nand2_1_2.B sky130_fd_sc_hd__nand2_1_2.B vss sky130_fd_sc_hd__nand2_1_59.VNB sky130_fd_pr__nfet_01v8 ad=0.169 pd=1.82 as=0.169 ps=1.82 w=0.65 l=0.15
X10 sky130_fd_sc_hd__inv_1_77.A sky130_fd_sc_hd__inv_1_78.A vdd sky130_fd_sc_hd__nand2_1_36.VPB sky130_fd_pr__pfet_01v8_hvt ad=0.26 pd=2.52 as=0.26 ps=2.52 w=1 l=0.15
X11 a_1861_8527# sky130_fd_sc_hd__nand2_1_4.B vss sky130_fd_sc_hd__nand2_1_59.VNB sky130_fd_pr__nfet_01v8 ad=0.08775 pd=0.92 as=0.169 ps=1.82 w=0.65 l=0.15
X12 vdd sky130_fd_sc_hd__nand2_1_2.B a_753_7119# sky130_fd_sc_hd__nand2_1_9.VPB sky130_fd_pr__pfet_01v8_hvt ad=0.26 pd=2.52 as=0.105 ps=1.21 w=1 l=0.15
X13 sky130_fd_sc_hd__nand2_1_2.B sample vss sky130_fd_sc_hd__nand2_1_59.VNB sky130_fd_pr__nfet_01v8 ad=0.169 pd=1.82 as=0.169 ps=1.82 w=0.65 l=0.15
X14 a_5089_3311# sky130_fd_sc_hd__nand2_1_33.B vss sky130_fd_sc_hd__nand2_1_59.VNB sky130_fd_pr__nfet_01v8 ad=0.08775 pd=0.92 as=0.169 ps=1.82 w=0.65 l=0.15
X15 sky130_fd_sc_hd__nand2_1_2.B sky130_fd_sc_hd__nand2_1_2.A a_193_6351# sky130_fd_sc_hd__nand2_1_59.VNB sky130_fd_pr__nfet_01v8 ad=0.169 pd=1.82 as=0.10725 ps=0.98 w=0.65 l=0.15
X16 sky130_fd_sc_hd__inv_1_142.A sky130_fd_sc_hd__inv_1_143.A vss sky130_fd_sc_hd__nand2_1_59.VNB sky130_fd_pr__nfet_01v8 ad=0.169 pd=1.82 as=0.169 ps=1.82 w=0.65 l=0.15
X17 sky130_fd_sc_hd__inv_1_38.A sky130_fd_sc_hd__nand2_1_2.B vss sky130_fd_sc_hd__nand2_1_59.VNB sky130_fd_pr__nfet_01v8 ad=0.169 pd=1.82 as=0.169 ps=1.82 w=0.65 l=0.15
X18 sky130_fd_sc_hd__inv_1_80.A sky130_fd_sc_hd__inv_1_81.A vss sky130_fd_sc_hd__nand2_1_59.VNB sky130_fd_pr__nfet_01v8 ad=0.169 pd=1.82 as=0.169 ps=1.82 w=0.65 l=0.15
X19 sky130_fd_sc_hd__nand2_1_12.B sky130_fd_sc_hd__inv_1_12.A vdd sky130_fd_sc_hd__nand2_1_9.VPB sky130_fd_pr__pfet_01v8_hvt ad=0.26 pd=2.52 as=0.26 ps=2.52 w=1 l=0.15
X20 sky130_fd_sc_hd__inv_1_51.A sky130_fd_sc_hd__inv_1_52.A vdd sky130_fd_sc_hd__nand2_1_28.VPB sky130_fd_pr__pfet_01v8_hvt ad=0.26 pd=2.52 as=0.26 ps=2.52 w=1 l=0.15
X21 a_5641_4399# sky130_fd_sc_hd__nand2_1_24.B vss sky130_fd_sc_hd__nand2_1_59.VNB sky130_fd_pr__nfet_01v8 ad=0.08775 pd=0.92 as=0.169 ps=1.82 w=0.65 l=0.15
X22 sky130_fd_sc_hd__nand2_1_29.B sky130_fd_sc_hd__nand2_1_2.B vdd sky130_fd_sc_hd__nand2_1_28.VPB sky130_fd_pr__pfet_01v8_hvt ad=0.26 pd=2.52 as=0.26 ps=2.52 w=1 l=0.15
X23 vdd sky130_fd_sc_hd__nand2_1_2.B a_753_6031# sky130_fd_sc_hd__nand2_1_15.VPB sky130_fd_pr__pfet_01v8_hvt ad=0.26 pd=2.52 as=0.105 ps=1.21 w=1 l=0.15
X24 sky130_fd_sc_hd__inv_1_21.A sky130_fd_sc_hd__nand2_1_2.B vdd sky130_fd_sc_hd__nand2_1_21.VPB sky130_fd_pr__pfet_01v8_hvt ad=0.135 pd=1.27 as=0.26 ps=2.52 w=1 l=0.15
X25 sky130_fd_sc_hd__inv_1_149.A sky130_fd_sc_hd__inv_1_150.A vdd sky130_fd_sc_hd__nand2_1_52.VPB sky130_fd_pr__pfet_01v8_hvt ad=0.26 pd=2.52 as=0.26 ps=2.52 w=1 l=0.15
X26 sky130_fd_sc_hd__nand2_1_10.B sky130_fd_sc_hd__nand2_1_2.B vdd sky130_fd_sc_hd__nand2_1_9.VPB sky130_fd_pr__pfet_01v8_hvt ad=0.26 pd=2.52 as=0.26 ps=2.52 w=1 l=0.15
X27 bit6_b sky130_fd_sc_hd__nand2_1_18.B vdd sky130_fd_sc_hd__nand2_1_15.VPB sky130_fd_pr__pfet_01v8_hvt ad=0.135 pd=1.27 as=0.26 ps=2.52 w=1 l=0.15
X28 vdd sky130_fd_sc_hd__nand2_1_40.Y sky130_fd_sc_hd__nand2_1_2.B sky130_fd_sc_hd__nand2_1_36.VPB sky130_fd_pr__pfet_01v8_hvt ad=0.26 pd=2.52 as=0.135 ps=1.27 w=1 l=0.15
X29 sky130_fd_sc_hd__inv_1_90.A sky130_fd_sc_hd__nand2_1_2.A vdd sky130_fd_sc_hd__nand2_1_36.VPB sky130_fd_pr__pfet_01v8_hvt ad=0.26 pd=2.52 as=0.26 ps=2.52 w=1 l=0.15
X30 sky130_fd_sc_hd__nand2_1_2.B sky130_fd_sc_hd__nand2_1_48.Y a_5089_1135# sky130_fd_sc_hd__nand2_1_59.VNB sky130_fd_pr__nfet_01v8 ad=0.169 pd=1.82 as=0.08775 ps=0.92 w=0.65 l=0.15
X31 sky130_fd_sc_hd__inv_1_120.A sky130_fd_sc_hd__nand2_1_2.A vss sky130_fd_sc_hd__nand2_1_59.VNB sky130_fd_pr__nfet_01v8 ad=0.169 pd=1.82 as=0.169 ps=1.82 w=0.65 l=0.15
X32 sky130_fd_sc_hd__nand2_1_2.B sky130_fd_sc_hd__inv_1_88.A vdd sky130_fd_sc_hd__nand2_1_36.VPB sky130_fd_pr__pfet_01v8_hvt ad=0.26 pd=2.52 as=0.26 ps=2.52 w=1 l=0.15
X33 sky130_fd_sc_hd__inv_1_115.A sky130_fd_sc_hd__nand2_1_2.B vdd sky130_fd_sc_hd__nand2_1_44.VPB sky130_fd_pr__pfet_01v8_hvt ad=0.135 pd=1.27 as=0.26 ps=2.52 w=1 l=0.15
X34 sky130_fd_sc_hd__nand2_1_16.B sky130_fd_sc_hd__nand2_1_2.B vdd sky130_fd_sc_hd__nand2_1_15.VPB sky130_fd_pr__pfet_01v8_hvt ad=0.26 pd=2.52 as=0.26 ps=2.52 w=1 l=0.15
X35 vdd sky130_fd_sc_hd__nand2_1_2.B sky130_fd_sc_hd__nand2_1_2.B sky130_fd_sc_hd__nand2_1_52.VPB sky130_fd_pr__pfet_01v8_hvt ad=0.26 pd=2.52 as=0.135 ps=1.27 w=1 l=0.15
X36 sky130_fd_sc_hd__nand2_1_2.B sky130_fd_sc_hd__inv_1_118.A vss sky130_fd_sc_hd__nand2_1_59.VNB sky130_fd_pr__nfet_01v8 ad=0.169 pd=1.82 as=0.169 ps=1.82 w=0.65 l=0.15
X37 sky130_fd_sc_hd__nand2_1_48.Y sky130_fd_sc_hd__nand2_1_48.B vdd sky130_fd_sc_hd__nand2_1_44.VPB sky130_fd_pr__pfet_01v8_hvt ad=0.135 pd=1.27 as=0.26 ps=2.52 w=1 l=0.15
X38 comp_clk sky130_fd_sc_hd__inv_1_145.A vss sky130_fd_sc_hd__nand2_1_59.VNB sky130_fd_pr__nfet_01v8 ad=0.169 pd=1.82 as=0.169 ps=1.82 w=0.65 l=0.15
X39 sky130_fd_sc_hd__inv_1_111.A sky130_fd_sc_hd__inv_1_112.A vss sky130_fd_sc_hd__nand2_1_59.VNB sky130_fd_pr__nfet_01v8 ad=0.169 pd=1.82 as=0.169 ps=1.82 w=0.65 l=0.15
X40 sky130_fd_sc_hd__inv_1_45.A sky130_fd_sc_hd__nand2_1_2.A vdd sky130_fd_sc_hd__nand2_1_28.VPB sky130_fd_pr__pfet_01v8_hvt ad=0.26 pd=2.52 as=0.26 ps=2.52 w=1 l=0.15
X41 sky130_fd_sc_hd__nand2_1_36.Y sky130_fd_sc_hd__nand2_1_2.B a_5365_3087# sky130_fd_sc_hd__nand2_1_59.VNB sky130_fd_pr__nfet_01v8 ad=0.169 pd=1.82 as=0.08775 ps=0.92 w=0.65 l=0.15
X42 vdd sky130_fd_sc_hd__nand2_1_28.Y sky130_fd_sc_hd__nand2_1_2.B sky130_fd_sc_hd__nand2_1_28.VPB sky130_fd_pr__pfet_01v8_hvt ad=0.26 pd=2.52 as=0.135 ps=1.27 w=1 l=0.15
X43 sky130_fd_sc_hd__nand2_1_7.B sky130_fd_sc_hd__nand2_1_2.B vss sky130_fd_sc_hd__nand2_1_59.VNB sky130_fd_pr__nfet_01v8 ad=0.169 pd=1.82 as=0.169 ps=1.82 w=0.65 l=0.15
X44 sky130_fd_sc_hd__nand2_1_45.B sky130_fd_sc_hd__nand2_1_2.B vss sky130_fd_sc_hd__nand2_1_59.VNB sky130_fd_pr__nfet_01v8 ad=0.169 pd=1.82 as=0.169 ps=1.82 w=0.65 l=0.15
X45 sky130_fd_sc_hd__nand2_1_2.B sample vss sky130_fd_sc_hd__nand2_1_59.VNB sky130_fd_pr__nfet_01v8 ad=0.08775 pd=0.92 as=0.169 ps=1.82 w=0.65 l=0.15
X46 bit6 sky130_fd_sc_hd__nand2_1_19.B vdd sky130_fd_sc_hd__nand2_1_15.VPB sky130_fd_pr__pfet_01v8_hvt ad=0.135 pd=1.27 as=0.26 ps=2.52 w=1 l=0.15
X47 sky130_fd_sc_hd__inv_1_48.A sky130_fd_sc_hd__inv_1_49.A vss sky130_fd_sc_hd__nand2_1_59.VNB sky130_fd_pr__nfet_01v8 ad=0.169 pd=1.82 as=0.169 ps=1.82 w=0.65 l=0.15
X48 vdd sky130_fd_sc_hd__nand2_1_2.B sky130_fd_sc_hd__nand2_1_52.Y sky130_fd_sc_hd__nand2_1_52.VPB sky130_fd_pr__pfet_01v8_hvt ad=0.26 pd=2.52 as=0.135 ps=1.27 w=1 l=0.15
X49 bit3 bit3_b a_1861_7439# sky130_fd_sc_hd__nand2_1_59.VNB sky130_fd_pr__nfet_01v8 ad=0.169 pd=1.82 as=0.08775 ps=0.92 w=0.65 l=0.15
X50 sky130_fd_sc_hd__inv_1_70.A sky130_fd_sc_hd__nand2_1_2.B vdd sky130_fd_sc_hd__nand2_1_36.VPB sky130_fd_pr__pfet_01v8_hvt ad=0.135 pd=1.27 as=0.26 ps=2.52 w=1 l=0.15
X51 sky130_fd_sc_hd__nand2_1_2.B sky130_fd_sc_hd__inv_1_43.A vdd sky130_fd_sc_hd__nand2_1_28.VPB sky130_fd_pr__pfet_01v8_hvt ad=0.26 pd=2.52 as=0.26 ps=2.52 w=1 l=0.15
X52 sky130_fd_sc_hd__inv_1_137.A sky130_fd_sc_hd__inv_1_138.A vdd sky130_fd_sc_hd__nand2_1_52.VPB sky130_fd_pr__pfet_01v8_hvt ad=0.26 pd=2.52 as=0.26 ps=2.52 w=1 l=0.15
X53 sky130_fd_sc_hd__inv_1_64.A sky130_fd_sc_hd__inv_1_65.A vss sky130_fd_sc_hd__nand2_1_59.VNB sky130_fd_pr__nfet_01v8 ad=0.169 pd=1.82 as=0.169 ps=1.82 w=0.65 l=0.15
X54 vdd sky130_fd_sc_hd__nand2_1_2.A sky130_fd_sc_hd__inv_1_24.A sky130_fd_sc_hd__nand2_1_21.VPB sky130_fd_pr__pfet_01v8_hvt ad=0.26 pd=2.52 as=0.135 ps=1.27 w=1 l=0.15
X55 sky130_fd_sc_hd__nand2_1_32.B sky130_fd_sc_hd__inv_1_55.A vdd sky130_fd_sc_hd__nand2_1_28.VPB sky130_fd_pr__pfet_01v8_hvt ad=0.26 pd=2.52 as=0.26 ps=2.52 w=1 l=0.15
X56 sky130_fd_sc_hd__inv_1_32.A sky130_fd_sc_hd__inv_1_33.A vss sky130_fd_sc_hd__nand2_1_59.VNB sky130_fd_pr__nfet_01v8 ad=0.169 pd=1.82 as=0.169 ps=1.82 w=0.65 l=0.15
X57 sky130_fd_sc_hd__nand2_1_55.B sky130_fd_sc_hd__inv_1_137.A vss sky130_fd_sc_hd__nand2_1_59.VNB sky130_fd_pr__nfet_01v8 ad=0.169 pd=1.82 as=0.169 ps=1.82 w=0.65 l=0.15
X58 sky130_fd_sc_hd__nand2_1_36.Y sky130_fd_sc_hd__nand2_1_36.B vdd sky130_fd_sc_hd__nand2_1_36.VPB sky130_fd_pr__pfet_01v8_hvt ad=0.135 pd=1.27 as=0.26 ps=2.52 w=1 l=0.15
X59 bit5 bit5_b a_1861_6351# sky130_fd_sc_hd__nand2_1_59.VNB sky130_fd_pr__nfet_01v8 ad=0.169 pd=1.82 as=0.08775 ps=0.92 w=0.65 l=0.15
X60 sky130_fd_sc_hd__nand2_1_2.B sample vss sky130_fd_sc_hd__nand2_1_59.VNB sky130_fd_pr__nfet_01v8 ad=0.08775 pd=0.92 as=0.169 ps=1.82 w=0.65 l=0.15
X61 vdd sky130_fd_sc_hd__nand2_1_2.B sky130_fd_sc_hd__nand2_1_24.Y sky130_fd_sc_hd__nand2_1_21.VPB sky130_fd_pr__pfet_01v8_hvt ad=0.26 pd=2.52 as=0.135 ps=1.27 w=1 l=0.15
X62 sky130_fd_sc_hd__nand2_1_40.B sky130_fd_sc_hd__inv_1_85.A vss sky130_fd_sc_hd__nand2_1_59.VNB sky130_fd_pr__nfet_01v8 ad=0.169 pd=1.82 as=0.169 ps=1.82 w=0.65 l=0.15
X63 sky130_fd_sc_hd__nand2_1_2.A sky130_fd_sc_hd__nand2_1_43.B vdd sky130_fd_sc_hd__nand2_1_36.VPB sky130_fd_pr__pfet_01v8_hvt ad=0.135 pd=1.27 as=0.26 ps=2.52 w=1 l=0.15
X64 sky130_fd_sc_hd__nand2_1_35.B sky130_fd_sc_hd__inv_1_62.A vss sky130_fd_sc_hd__nand2_1_59.VNB sky130_fd_pr__nfet_01v8 ad=0.169 pd=1.82 as=0.169 ps=1.82 w=0.65 l=0.15
X65 sky130_fd_sc_hd__nand2_1_2.A sky130_fd_sc_hd__nand2_1_2.A vdd sky130_fd_sc_hd__nand2_1_21.VPB sky130_fd_pr__pfet_01v8_hvt ad=0.26 pd=2.52 as=0.165 ps=1.33 w=1 l=0.15
X66 sky130_fd_sc_hd__nand2_1_2.A sky130_fd_sc_hd__nand2_1_2.A a_2321_4175# sky130_fd_sc_hd__nand2_1_59.VNB sky130_fd_pr__nfet_01v8 ad=0.169 pd=1.82 as=0.08775 ps=0.92 w=0.65 l=0.15
X67 a_2321_1135# sky130_fd_sc_hd__nand2_1_51.B vss sky130_fd_sc_hd__nand2_1_59.VNB sky130_fd_pr__nfet_01v8 ad=0.08775 pd=0.92 as=0.169 ps=1.82 w=0.65 l=0.15
X68 a_1309_6575# sky130_fd_sc_hd__nand2_1_2.B vss sky130_fd_sc_hd__nand2_1_59.VNB sky130_fd_pr__nfet_01v8 ad=0.08775 pd=0.92 as=0.169 ps=1.82 w=0.65 l=0.15
X69 sky130_fd_sc_hd__inv_1_110.A sky130_fd_sc_hd__inv_1_111.A vdd sky130_fd_sc_hd__nand2_1_44.VPB sky130_fd_pr__pfet_01v8_hvt ad=0.26 pd=2.52 as=0.26 ps=2.52 w=1 l=0.15
X70 sky130_fd_sc_hd__nand2_1_2.B sky130_fd_sc_hd__nand2_1_44.Y a_5089_1999# sky130_fd_sc_hd__nand2_1_59.VNB sky130_fd_pr__nfet_01v8 ad=0.169 pd=1.82 as=0.08775 ps=0.92 w=0.65 l=0.15
X71 sky130_fd_sc_hd__inv_1_105.A sky130_fd_sc_hd__nand2_1_2.A vss sky130_fd_sc_hd__nand2_1_59.VNB sky130_fd_pr__nfet_01v8 ad=0.169 pd=1.82 as=0.169 ps=1.82 w=0.65 l=0.15
X72 a_3149_47# sky130_fd_sc_hd__nand2_1_58.B vss sky130_fd_sc_hd__nand2_1_59.VNB sky130_fd_pr__nfet_01v8 ad=0.08775 pd=0.92 as=0.169 ps=1.82 w=0.65 l=0.15
X73 vdd outn sky130_fd_sc_hd__nand2_1_2.A sky130_fd_sc_hd__nand2_1_9.VPB sky130_fd_pr__pfet_01v8_hvt ad=0.165 pd=1.33 as=0.135 ps=1.27 w=1 l=0.15
X74 sky130_fd_sc_hd__inv_1_147.A sky130_fd_sc_hd__inv_1_148.A vss sky130_fd_sc_hd__nand2_1_59.VNB sky130_fd_pr__nfet_01v8 ad=0.169 pd=1.82 as=0.169 ps=1.82 w=0.65 l=0.15
X75 sky130_fd_sc_hd__nand2_1_3.B sky130_fd_sc_hd__inv_1_3.A vdd sky130_fd_sc_hd__nand2_1_3.VPB sky130_fd_pr__pfet_01v8_hvt ad=0.26 pd=2.52 as=0.26 ps=2.52 w=1 l=0.15
X76 sky130_fd_sc_hd__nand2_1_2.B sky130_fd_sc_hd__inv_1_103.A vss sky130_fd_sc_hd__nand2_1_59.VNB sky130_fd_pr__nfet_01v8 ad=0.169 pd=1.82 as=0.169 ps=1.82 w=0.65 l=0.15
X77 a_5077_297# sky130_fd_sc_hd__nand2_1_2.B sky130_fd_sc_hd__inv_1_145.A sky130_fd_sc_hd__nand2_1_52.VPB sky130_fd_pr__pfet_01v8_hvt ad=0.105 pd=1.21 as=0.26 ps=2.52 w=1 l=0.15
X78 vdd sky130_fd_sc_hd__nand2_1_2.B a_3697_297# sky130_fd_sc_hd__nand2_1_52.VPB sky130_fd_pr__pfet_01v8_hvt ad=0.26 pd=2.52 as=0.105 ps=1.21 w=1 l=0.15
X79 sky130_fd_sc_hd__nand2_1_2.A sky130_fd_sc_hd__nand2_1_31.B vdd sky130_fd_sc_hd__nand2_1_28.VPB sky130_fd_pr__pfet_01v8_hvt ad=0.135 pd=1.27 as=0.26 ps=2.52 w=1 l=0.15
X80 sky130_fd_sc_hd__nand2_1_2.B sample vdd sky130_fd_sc_hd__nand2_1_0.VPB sky130_fd_pr__pfet_01v8_hvt ad=0.26 pd=2.52 as=0.26 ps=2.52 w=1 l=0.15
X81 bit3_b sky130_fd_sc_hd__nand2_1_9.B vdd sky130_fd_sc_hd__nand2_1_9.VPB sky130_fd_pr__pfet_01v8_hvt ad=0.135 pd=1.27 as=0.26 ps=2.52 w=1 l=0.15
X82 sky130_fd_sc_hd__inv_1_123.A sky130_fd_sc_hd__inv_1_124.A vdd sky130_fd_sc_hd__nand2_1_44.VPB sky130_fd_pr__pfet_01v8_hvt ad=0.26 pd=2.52 as=0.26 ps=2.52 w=1 l=0.15
X83 sky130_fd_sc_hd__inv_1_97.A sky130_fd_sc_hd__inv_1_98.A vdd sky130_fd_sc_hd__nand2_1_36.VPB sky130_fd_pr__pfet_01v8_hvt ad=0.26 pd=2.52 as=0.26 ps=2.52 w=1 l=0.15
X84 vdd sky130_fd_sc_hd__nand2_1_2.B sky130_fd_sc_hd__nand2_1_2.B sky130_fd_sc_hd__nand2_1_52.VPB sky130_fd_pr__pfet_01v8_hvt ad=0.26 pd=2.52 as=0.135 ps=1.27 w=1 l=0.15
X85 sky130_fd_sc_hd__inv_1_146.A sky130_fd_sc_hd__inv_1_147.A vss sky130_fd_sc_hd__nand2_1_59.VNB sky130_fd_pr__nfet_01v8 ad=0.169 pd=1.82 as=0.169 ps=1.82 w=0.65 l=0.15
X86 sky130_fd_sc_hd__inv_1_127.A sky130_fd_sc_hd__inv_1_128.A vss sky130_fd_sc_hd__nand2_1_59.VNB sky130_fd_pr__nfet_01v8 ad=0.169 pd=1.82 as=0.169 ps=1.82 w=0.65 l=0.15
X87 a_753_7913# sample sky130_fd_sc_hd__nand2_1_2.B sky130_fd_sc_hd__nand2_1_3.VPB sky130_fd_pr__pfet_01v8_hvt ad=0.105 pd=1.21 as=0.26 ps=2.52 w=1 l=0.15
X88 a_5089_4175# sky130_fd_sc_hd__nand2_1_29.B vss sky130_fd_sc_hd__nand2_1_59.VNB sky130_fd_pr__nfet_01v8 ad=0.08775 pd=0.92 as=0.169 ps=1.82 w=0.65 l=0.15
X89 sky130_fd_sc_hd__nand2_1_2.B sample vdd sky130_fd_sc_hd__nand2_1_52.VPB sky130_fd_pr__pfet_01v8_hvt ad=0.26 pd=2.52 as=0.26 ps=2.52 w=1 l=0.15
X90 sky130_fd_sc_hd__nand2_1_0.B sky130_fd_sc_hd__inv_1_0.A vss sky130_fd_sc_hd__nand2_1_59.VNB sky130_fd_pr__nfet_01v8 ad=0.169 pd=1.82 as=0.169 ps=1.82 w=0.65 l=0.15
X91 bit5_b sky130_fd_sc_hd__nand2_1_15.B vdd sky130_fd_sc_hd__nand2_1_15.VPB sky130_fd_pr__pfet_01v8_hvt ad=0.135 pd=1.27 as=0.26 ps=2.52 w=1 l=0.15
X92 vdd sky130_fd_sc_hd__nand2_1_2.B a_4257_4649# sky130_fd_sc_hd__nand2_1_21.VPB sky130_fd_pr__pfet_01v8_hvt ad=0.26 pd=2.52 as=0.105 ps=1.21 w=1 l=0.15
X93 vdd sky130_fd_sc_hd__nand2_1_52.Y sky130_fd_sc_hd__nand2_1_2.B sky130_fd_sc_hd__nand2_1_52.VPB sky130_fd_pr__pfet_01v8_hvt ad=0.26 pd=2.52 as=0.135 ps=1.27 w=1 l=0.15
X94 sky130_fd_sc_hd__nand2_1_2.B sky130_fd_sc_hd__nand2_1_2.B vdd sky130_fd_sc_hd__nand2_1_52.VPB sky130_fd_pr__pfet_01v8_hvt ad=0.135 pd=1.27 as=0.26 ps=2.52 w=1 l=0.15
X95 vdd sky130_fd_sc_hd__nand2_1_2.B sky130_fd_sc_hd__nand2_1_44.Y sky130_fd_sc_hd__nand2_1_44.VPB sky130_fd_pr__pfet_01v8_hvt ad=0.26 pd=2.52 as=0.135 ps=1.27 w=1 l=0.15
X96 vdd sky130_fd_sc_hd__nand2_1_2.A sky130_fd_sc_hd__nand2_1_2.A sky130_fd_sc_hd__nand2_1_44.VPB sky130_fd_pr__pfet_01v8_hvt ad=0.26 pd=2.52 as=0.135 ps=1.27 w=1 l=0.15
X97 sky130_fd_sc_hd__inv_1_78.A sky130_fd_sc_hd__inv_1_79.A vdd sky130_fd_sc_hd__nand2_1_36.VPB sky130_fd_pr__pfet_01v8_hvt ad=0.26 pd=2.52 as=0.26 ps=2.52 w=1 l=0.15
X98 sky130_fd_sc_hd__inv_1_52.A sky130_fd_sc_hd__inv_1_53.A vdd sky130_fd_sc_hd__nand2_1_28.VPB sky130_fd_pr__pfet_01v8_hvt ad=0.26 pd=2.52 as=0.26 ps=2.52 w=1 l=0.15
X99 a_2137_7663# sky130_fd_sc_hd__nand2_1_6.B vss sky130_fd_sc_hd__nand2_1_59.VNB sky130_fd_pr__nfet_01v8 ad=0.08775 pd=0.92 as=0.169 ps=1.82 w=0.65 l=0.15
X100 bit3 sky130_fd_sc_hd__nand2_1_10.B vdd sky130_fd_sc_hd__nand2_1_9.VPB sky130_fd_pr__pfet_01v8_hvt ad=0.135 pd=1.27 as=0.26 ps=2.52 w=1 l=0.15
X101 a_5365_4399# sky130_fd_sc_hd__nand2_1_25.B vss sky130_fd_sc_hd__nand2_1_59.VNB sky130_fd_pr__nfet_01v8 ad=0.08775 pd=0.92 as=0.169 ps=1.82 w=0.65 l=0.15
X102 vss sky130_fd_sc_hd__nand2_1_2.B sky130_fd_sc_hd__inv_1_145.A sky130_fd_sc_hd__nand2_1_59.VNB sky130_fd_pr__nfet_01v8 ad=0.169 pd=1.82 as=0.08775 ps=0.92 w=0.65 l=0.15
X103 a_2321_1999# sky130_fd_sc_hd__nand2_1_47.B vss sky130_fd_sc_hd__nand2_1_59.VNB sky130_fd_pr__nfet_01v8 ad=0.08775 pd=0.92 as=0.169 ps=1.82 w=0.65 l=0.15
X104 sky130_fd_sc_hd__nand2_1_52.Y sky130_fd_sc_hd__nand2_1_52.B vdd sky130_fd_sc_hd__nand2_1_52.VPB sky130_fd_pr__pfet_01v8_hvt ad=0.135 pd=1.27 as=0.26 ps=2.52 w=1 l=0.15
X105 sky130_fd_sc_hd__nand2_1_21.B sky130_fd_sc_hd__inv_1_21.A vss sky130_fd_sc_hd__nand2_1_59.VNB sky130_fd_pr__nfet_01v8 ad=0.169 pd=1.82 as=0.169 ps=1.82 w=0.65 l=0.15
X106 sky130_fd_sc_hd__nand2_1_2.A sky130_fd_sc_hd__nand2_1_2.A a_193_6575# sky130_fd_sc_hd__nand2_1_59.VNB sky130_fd_pr__nfet_01v8 ad=0.169 pd=1.82 as=0.10725 ps=0.98 w=0.65 l=0.15
X107 vdd bit7_b bit7 sky130_fd_sc_hd__nand2_1_21.VPB sky130_fd_pr__pfet_01v8_hvt ad=0.26 pd=2.52 as=0.135 ps=1.27 w=1 l=0.15
X108 sky130_fd_sc_hd__nand2_1_2.B sky130_fd_sc_hd__inv_1_133.A vss sky130_fd_sc_hd__nand2_1_59.VNB sky130_fd_pr__nfet_01v8 ad=0.169 pd=1.82 as=0.169 ps=1.82 w=0.65 l=0.15
X109 bit5 sky130_fd_sc_hd__nand2_1_16.B vdd sky130_fd_sc_hd__nand2_1_15.VPB sky130_fd_pr__pfet_01v8_hvt ad=0.135 pd=1.27 as=0.26 ps=2.52 w=1 l=0.15
X110 sky130_fd_sc_hd__inv_1_88.A sky130_fd_sc_hd__inv_1_89.A vdd sky130_fd_sc_hd__nand2_1_36.VPB sky130_fd_pr__pfet_01v8_hvt ad=0.26 pd=2.52 as=0.26 ps=2.52 w=1 l=0.15
X111 vdd sky130_fd_sc_hd__nand2_1_2.A sky130_fd_sc_hd__inv_1_12.A sky130_fd_sc_hd__nand2_1_9.VPB sky130_fd_pr__pfet_01v8_hvt ad=0.26 pd=2.52 as=0.135 ps=1.27 w=1 l=0.15
X112 vdd sky130_fd_sc_hd__nand2_1_2.A sky130_fd_sc_hd__nand2_1_2.A sky130_fd_sc_hd__nand2_1_36.VPB sky130_fd_pr__pfet_01v8_hvt ad=0.26 pd=2.52 as=0.135 ps=1.27 w=1 l=0.15
X113 comp_clk sky130_fd_sc_hd__inv_1_145.A vdd sky130_fd_sc_hd__nand2_1_52.VPB sky130_fd_pr__pfet_01v8_hvt ad=0.26 pd=2.52 as=0.26 ps=2.52 w=1 l=0.15
X114 sky130_fd_sc_hd__inv_1_118.A sky130_fd_sc_hd__inv_1_119.A vss sky130_fd_sc_hd__nand2_1_59.VNB sky130_fd_pr__nfet_01v8 ad=0.169 pd=1.82 as=0.169 ps=1.82 w=0.65 l=0.15
X115 sky130_fd_sc_hd__nand2_1_2.B sample vss sky130_fd_sc_hd__nand2_1_59.VNB sky130_fd_pr__nfet_01v8 ad=0.08775 pd=0.92 as=0.169 ps=1.82 w=0.65 l=0.15
X116 sky130_fd_sc_hd__nand2_1_2.B sample vss sky130_fd_sc_hd__nand2_1_59.VNB sky130_fd_pr__nfet_01v8 ad=0.169 pd=1.82 as=0.169 ps=1.82 w=0.65 l=0.15
X117 a_1861_7663# sky130_fd_sc_hd__nand2_1_7.B vss sky130_fd_sc_hd__nand2_1_59.VNB sky130_fd_pr__nfet_01v8 ad=0.08775 pd=0.92 as=0.169 ps=1.82 w=0.65 l=0.15
X118 vdd bit4 bit4_b sky130_fd_sc_hd__nand2_1_9.VPB sky130_fd_pr__pfet_01v8_hvt ad=0.26 pd=2.52 as=0.135 ps=1.27 w=1 l=0.15
X119 sky130_fd_sc_hd__nand2_1_2.B sky130_fd_sc_hd__nand2_1_2.B vdd sky130_fd_sc_hd__nand2_1_44.VPB sky130_fd_pr__pfet_01v8_hvt ad=0.135 pd=1.27 as=0.26 ps=2.52 w=1 l=0.15
X120 sky130_fd_sc_hd__nand2_1_58.B sky130_fd_sc_hd__inv_1_146.A vdd sky130_fd_sc_hd__nand2_1_52.VPB sky130_fd_pr__pfet_01v8_hvt ad=0.26 pd=2.52 as=0.26 ps=2.52 w=1 l=0.15
X121 sky130_fd_sc_hd__inv_1_112.A sky130_fd_sc_hd__inv_1_113.A vss sky130_fd_sc_hd__nand2_1_59.VNB sky130_fd_pr__nfet_01v8 ad=0.169 pd=1.82 as=0.169 ps=1.82 w=0.65 l=0.15
X122 vdd sky130_fd_sc_hd__nand2_1_2.B a_3421_297# sky130_fd_sc_hd__nand2_1_52.VPB sky130_fd_pr__pfet_01v8_hvt ad=0.26 pd=2.52 as=0.105 ps=1.21 w=1 l=0.15
X123 vss sky130_fd_sc_hd__nand2_1_2.B sky130_fd_sc_hd__nand2_1_2.B sky130_fd_sc_hd__nand2_1_59.VNB sky130_fd_pr__nfet_01v8 ad=0.169 pd=1.82 as=0.08775 ps=0.92 w=0.65 l=0.15
X124 vdd outn outn sky130_fd_sc_hd__nand2_1_3.VPB sky130_fd_pr__pfet_01v8_hvt ad=0.165 pd=1.33 as=0.135 ps=1.27 w=1 l=0.15
X125 sky130_fd_sc_hd__nand2_1_2.A sky130_fd_sc_hd__nand2_1_2.B vdd sky130_fd_sc_hd__nand2_1_9.VPB sky130_fd_pr__pfet_01v8_hvt ad=0.135 pd=1.27 as=0.26 ps=2.52 w=1 l=0.15
X126 sky130_fd_sc_hd__nand2_1_25.B sky130_fd_sc_hd__inv_1_25.A vdd sky130_fd_sc_hd__nand2_1_21.VPB sky130_fd_pr__pfet_01v8_hvt ad=0.26 pd=2.52 as=0.26 ps=2.52 w=1 l=0.15
X127 vdd outp sky130_fd_sc_hd__inv_1_155.A sky130_fd_sc_hd__nand2_1_52.VPB sky130_fd_pr__pfet_01v8_hvt ad=0.26 pd=2.52 as=0.135 ps=1.27 w=1 l=0.15
X128 vdd sky130_fd_sc_hd__nand2_1_2.A sky130_fd_sc_hd__inv_1_85.A sky130_fd_sc_hd__nand2_1_36.VPB sky130_fd_pr__pfet_01v8_hvt ad=0.26 pd=2.52 as=0.135 ps=1.27 w=1 l=0.15
X129 sky130_fd_sc_hd__inv_1_49.A sky130_fd_sc_hd__inv_1_50.A vss sky130_fd_sc_hd__nand2_1_59.VNB sky130_fd_pr__nfet_01v8 ad=0.169 pd=1.82 as=0.169 ps=1.82 w=0.65 l=0.15
X130 sky130_fd_sc_hd__nand2_1_58.B sky130_fd_sc_hd__inv_1_146.A vss sky130_fd_sc_hd__nand2_1_59.VNB sky130_fd_pr__nfet_01v8 ad=0.169 pd=1.82 as=0.169 ps=1.82 w=0.65 l=0.15
X131 sky130_fd_sc_hd__nand2_1_2.B sample vdd sky130_fd_sc_hd__nand2_1_28.VPB sky130_fd_pr__pfet_01v8_hvt ad=0.26 pd=2.52 as=0.26 ps=2.52 w=1 l=0.15
X132 sky130_fd_sc_hd__inv_1_43.A sky130_fd_sc_hd__inv_1_44.A vdd sky130_fd_sc_hd__nand2_1_28.VPB sky130_fd_pr__pfet_01v8_hvt ad=0.26 pd=2.52 as=0.26 ps=2.52 w=1 l=0.15
X133 sky130_fd_sc_hd__inv_1_115.A sky130_fd_sc_hd__nand2_1_2.A a_4537_1135# sky130_fd_sc_hd__nand2_1_59.VNB sky130_fd_pr__nfet_01v8 ad=0.169 pd=1.82 as=0.08775 ps=0.92 w=0.65 l=0.15
X134 sky130_fd_sc_hd__inv_1_0.A sky130_fd_sc_hd__nand2_1_2.B vdd sky130_fd_sc_hd__nand2_1_0.VPB sky130_fd_pr__pfet_01v8_hvt ad=0.135 pd=1.27 as=0.26 ps=2.52 w=1 l=0.15
X135 vdd sky130_fd_sc_hd__nand2_1_2.B a_3981_591# sky130_fd_sc_hd__nand2_1_52.VPB sky130_fd_pr__pfet_01v8_hvt ad=0.26 pd=2.52 as=0.105 ps=1.21 w=1 l=0.15
X136 sky130_fd_sc_hd__inv_1_89.A sky130_fd_sc_hd__inv_1_90.A vdd sky130_fd_sc_hd__nand2_1_36.VPB sky130_fd_pr__pfet_01v8_hvt ad=0.26 pd=2.52 as=0.26 ps=2.52 w=1 l=0.15
X137 sky130_fd_sc_hd__nand2_1_31.B sky130_fd_sc_hd__inv_1_47.A vss sky130_fd_sc_hd__nand2_1_59.VNB sky130_fd_pr__nfet_01v8 ad=0.169 pd=1.82 as=0.169 ps=1.82 w=0.65 l=0.15
X138 a_3973_297# sky130_fd_sc_hd__nand2_1_2.B sky130_fd_sc_hd__nand2_1_2.B sky130_fd_sc_hd__nand2_1_52.VPB sky130_fd_pr__pfet_01v8_hvt ad=0.105 pd=1.21 as=0.26 ps=2.52 w=1 l=0.15
X139 sky130_fd_sc_hd__nand2_1_2.B sample vss sky130_fd_sc_hd__nand2_1_59.VNB sky130_fd_pr__nfet_01v8 ad=0.169 pd=1.82 as=0.169 ps=1.82 w=0.65 l=0.15
X140 sky130_fd_sc_hd__nand2_1_36.B sky130_fd_sc_hd__inv_1_70.A vss sky130_fd_sc_hd__nand2_1_59.VNB sky130_fd_pr__nfet_01v8 ad=0.169 pd=1.82 as=0.169 ps=1.82 w=0.65 l=0.15
X141 sky130_fd_sc_hd__nand2_1_2.B sky130_fd_sc_hd__nand2_1_37.B vdd sky130_fd_sc_hd__nand2_1_36.VPB sky130_fd_pr__pfet_01v8_hvt ad=0.135 pd=1.27 as=0.26 ps=2.52 w=1 l=0.15
X142 sky130_fd_sc_hd__inv_1_119.A sky130_fd_sc_hd__inv_1_120.A vss sky130_fd_sc_hd__nand2_1_59.VNB sky130_fd_pr__nfet_01v8 ad=0.169 pd=1.82 as=0.169 ps=1.82 w=0.65 l=0.15
X143 a_193_8751# outn a_109_8751# sky130_fd_sc_hd__nand2_1_59.VNB sky130_fd_pr__nfet_01v8 ad=0.10725 pd=0.98 as=0.08775 ps=0.92 w=0.65 l=0.15
X144 sky130_fd_sc_hd__inv_1_33.A sky130_fd_sc_hd__inv_1_34.A vss sky130_fd_sc_hd__nand2_1_59.VNB sky130_fd_pr__nfet_01v8 ad=0.169 pd=1.82 as=0.169 ps=1.82 w=0.65 l=0.15
X145 vdd sky130_fd_sc_hd__nand2_1_2.A sky130_fd_sc_hd__inv_1_40.A sky130_fd_sc_hd__nand2_1_28.VPB sky130_fd_pr__pfet_01v8_hvt ad=0.26 pd=2.52 as=0.135 ps=1.27 w=1 l=0.15
X146 sky130_fd_sc_hd__inv_1_134.A sky130_fd_sc_hd__inv_1_135.A vdd sky130_fd_sc_hd__nand2_1_52.VPB sky130_fd_pr__pfet_01v8_hvt ad=0.26 pd=2.52 as=0.26 ps=2.52 w=1 l=0.15
X147 sky130_fd_sc_hd__inv_1_44.A sky130_fd_sc_hd__inv_1_45.A vdd sky130_fd_sc_hd__nand2_1_28.VPB sky130_fd_pr__pfet_01v8_hvt ad=0.26 pd=2.52 as=0.26 ps=2.52 w=1 l=0.15
X148 sky130_fd_sc_hd__nand2_1_2.A sky130_fd_sc_hd__nand2_1_2.A a_2321_911# sky130_fd_sc_hd__nand2_1_59.VNB sky130_fd_pr__nfet_01v8 ad=0.169 pd=1.82 as=0.08775 ps=0.92 w=0.65 l=0.15
X149 a_3981_1385# sample sky130_fd_sc_hd__nand2_1_2.B sky130_fd_sc_hd__nand2_1_44.VPB sky130_fd_pr__pfet_01v8_hvt ad=0.105 pd=1.21 as=0.26 ps=2.52 w=1 l=0.15
X150 sky130_fd_sc_hd__nand2_1_2.B sample vdd sky130_fd_sc_hd__nand2_1_15.VPB sky130_fd_pr__pfet_01v8_hvt ad=0.26 pd=2.52 as=0.26 ps=2.52 w=1 l=0.15
X151 sky130_fd_sc_hd__inv_1_103.A sky130_fd_sc_hd__inv_1_104.A vss sky130_fd_sc_hd__nand2_1_59.VNB sky130_fd_pr__nfet_01v8 ad=0.169 pd=1.82 as=0.169 ps=1.82 w=0.65 l=0.15
X152 sky130_fd_sc_hd__inv_1_65.A sky130_fd_sc_hd__inv_1_66.A vss sky130_fd_sc_hd__nand2_1_59.VNB sky130_fd_pr__nfet_01v8 ad=0.169 pd=1.82 as=0.169 ps=1.82 w=0.65 l=0.15
X153 bit4 bit4_b a_1861_6575# sky130_fd_sc_hd__nand2_1_59.VNB sky130_fd_pr__nfet_01v8 ad=0.169 pd=1.82 as=0.08775 ps=0.92 w=0.65 l=0.15
X154 sky130_fd_sc_hd__nand2_1_2.A sky130_fd_sc_hd__nand2_1_2.A a_2321_4399# sky130_fd_sc_hd__nand2_1_59.VNB sky130_fd_pr__nfet_01v8 ad=0.169 pd=1.82 as=0.08775 ps=0.92 w=0.65 l=0.15
X155 vss sky130_fd_sc_hd__nand2_1_2.B sky130_fd_sc_hd__nand2_1_2.B sky130_fd_sc_hd__nand2_1_59.VNB sky130_fd_pr__nfet_01v8 ad=0.169 pd=1.82 as=0.08775 ps=0.92 w=0.65 l=0.15
X156 a_193_5263# outn a_109_5263# sky130_fd_sc_hd__nand2_1_59.VNB sky130_fd_pr__nfet_01v8 ad=0.10725 pd=0.98 as=0.08775 ps=0.92 w=0.65 l=0.15
X157 sky130_fd_sc_hd__inv_1_124.A sky130_fd_sc_hd__inv_1_125.A vdd sky130_fd_sc_hd__nand2_1_44.VPB sky130_fd_pr__pfet_01v8_hvt ad=0.26 pd=2.52 as=0.26 ps=2.52 w=1 l=0.15
X158 sky130_fd_sc_hd__nand2_1_2.B sample vss sky130_fd_sc_hd__nand2_1_59.VNB sky130_fd_pr__nfet_01v8 ad=0.08775 pd=0.92 as=0.169 ps=1.82 w=0.65 l=0.15
X159 sky130_fd_sc_hd__nand2_1_2.B sky130_fd_sc_hd__nand2_1_2.B vdd sky130_fd_sc_hd__nand2_1_52.VPB sky130_fd_pr__pfet_01v8_hvt ad=0.135 pd=1.27 as=0.26 ps=2.52 w=1 l=0.15
X160 sky130_fd_sc_hd__inv_1_98.A sky130_fd_sc_hd__nand2_1_2.B vdd sky130_fd_sc_hd__nand2_1_36.VPB sky130_fd_pr__pfet_01v8_hvt ad=0.26 pd=2.52 as=0.26 ps=2.52 w=1 l=0.15
X161 vdd outn sky130_fd_sc_hd__inv_1_3.A sky130_fd_sc_hd__nand2_1_3.VPB sky130_fd_pr__pfet_01v8_hvt ad=0.26 pd=2.52 as=0.135 ps=1.27 w=1 l=0.15
X162 sky130_fd_sc_hd__nand2_1_51.B sky130_fd_sc_hd__inv_1_122.A vdd sky130_fd_sc_hd__nand2_1_44.VPB sky130_fd_pr__pfet_01v8_hvt ad=0.26 pd=2.52 as=0.26 ps=2.52 w=1 l=0.15
X163 sky130_fd_sc_hd__inv_1_100.A sky130_fd_sc_hd__nand2_1_2.A a_4537_1999# sky130_fd_sc_hd__nand2_1_59.VNB sky130_fd_pr__nfet_01v8 ad=0.169 pd=1.82 as=0.08775 ps=0.92 w=0.65 l=0.15
X164 a_3981_2767# sample sky130_fd_sc_hd__nand2_1_2.B sky130_fd_sc_hd__nand2_1_36.VPB sky130_fd_pr__pfet_01v8_hvt ad=0.105 pd=1.21 as=0.26 ps=2.52 w=1 l=0.15
X165 vdd sky130_fd_sc_hd__nand2_1_2.B a_753_6825# sky130_fd_sc_hd__nand2_1_9.VPB sky130_fd_pr__pfet_01v8_hvt ad=0.26 pd=2.52 as=0.105 ps=1.21 w=1 l=0.15
X166 sky130_fd_sc_hd__inv_1_128.A sky130_fd_sc_hd__nand2_1_2.B vss sky130_fd_sc_hd__nand2_1_59.VNB sky130_fd_pr__nfet_01v8 ad=0.169 pd=1.82 as=0.169 ps=1.82 w=0.65 l=0.15
X167 sky130_fd_sc_hd__nand2_1_2.A sky130_fd_sc_hd__nand2_1_2.A vdd sky130_fd_sc_hd__nand2_1_0.VPB sky130_fd_pr__pfet_01v8_hvt ad=0.26 pd=2.52 as=0.165 ps=1.33 w=1 l=0.15
X168 a_1309_8527# sky130_fd_sc_hd__nand2_1_2.B vss sky130_fd_sc_hd__nand2_1_59.VNB sky130_fd_pr__nfet_01v8 ad=0.08775 pd=0.92 as=0.169 ps=1.82 w=0.65 l=0.15
X169 sky130_fd_sc_hd__inv_1_104.A sky130_fd_sc_hd__inv_1_105.A vss sky130_fd_sc_hd__nand2_1_59.VNB sky130_fd_pr__nfet_01v8 ad=0.169 pd=1.82 as=0.169 ps=1.82 w=0.65 l=0.15
X170 vdd bit1 bit1_b sky130_fd_sc_hd__nand2_1_3.VPB sky130_fd_pr__pfet_01v8_hvt ad=0.26 pd=2.52 as=0.135 ps=1.27 w=1 l=0.15
X171 sky130_fd_sc_hd__nand2_1_2.B sky130_fd_sc_hd__nand2_1_2.B a_4529_47# sky130_fd_sc_hd__nand2_1_59.VNB sky130_fd_pr__nfet_01v8 ad=0.169 pd=1.82 as=0.08775 ps=0.92 w=0.65 l=0.15
X172 sky130_fd_sc_hd__nand2_1_2.B sample vss sky130_fd_sc_hd__nand2_1_59.VNB sky130_fd_pr__nfet_01v8 ad=0.08775 pd=0.92 as=0.169 ps=1.82 w=0.65 l=0.15
X173 sky130_fd_sc_hd__nand2_1_2.B sky130_fd_sc_hd__nand2_1_2.B vdd sky130_fd_sc_hd__nand2_1_52.VPB sky130_fd_pr__pfet_01v8_hvt ad=0.135 pd=1.27 as=0.26 ps=2.52 w=1 l=0.15
X174 sky130_fd_sc_hd__inv_1_79.A sky130_fd_sc_hd__inv_1_80.A vdd sky130_fd_sc_hd__nand2_1_36.VPB sky130_fd_pr__pfet_01v8_hvt ad=0.26 pd=2.52 as=0.26 ps=2.52 w=1 l=0.15
X175 outn sky130_fd_sc_hd__nand2_1_2.B vdd sky130_fd_sc_hd__nand2_1_3.VPB sky130_fd_pr__pfet_01v8_hvt ad=0.135 pd=1.27 as=0.26 ps=2.52 w=1 l=0.15
X176 sky130_fd_sc_hd__nand2_1_32.Y sky130_fd_sc_hd__nand2_1_2.B a_5365_3311# sky130_fd_sc_hd__nand2_1_59.VNB sky130_fd_pr__nfet_01v8 ad=0.169 pd=1.82 as=0.08775 ps=0.92 w=0.65 l=0.15
X177 sky130_fd_sc_hd__nand2_1_13.B sky130_fd_sc_hd__nand2_1_2.B vdd sky130_fd_sc_hd__nand2_1_9.VPB sky130_fd_pr__pfet_01v8_hvt ad=0.26 pd=2.52 as=0.26 ps=2.52 w=1 l=0.15
X178 sky130_fd_sc_hd__inv_1_53.A sky130_fd_sc_hd__nand2_1_2.B vdd sky130_fd_sc_hd__nand2_1_28.VPB sky130_fd_pr__pfet_01v8_hvt ad=0.26 pd=2.52 as=0.26 ps=2.52 w=1 l=0.15
X179 sky130_fd_sc_hd__inv_1_133.A sky130_fd_sc_hd__inv_1_134.A vss sky130_fd_sc_hd__nand2_1_59.VNB sky130_fd_pr__nfet_01v8 ad=0.169 pd=1.82 as=0.169 ps=1.82 w=0.65 l=0.15
X180 sky130_fd_sc_hd__nand2_1_44.B sky130_fd_sc_hd__inv_1_100.A vdd sky130_fd_sc_hd__nand2_1_44.VPB sky130_fd_pr__pfet_01v8_hvt ad=0.26 pd=2.52 as=0.26 ps=2.52 w=1 l=0.15
X181 sky130_fd_sc_hd__nand2_1_39.B sky130_fd_sc_hd__inv_1_77.A vdd sky130_fd_sc_hd__nand2_1_36.VPB sky130_fd_pr__pfet_01v8_hvt ad=0.26 pd=2.52 as=0.26 ps=2.52 w=1 l=0.15
X182 sky130_fd_sc_hd__inv_1_0.A sky130_fd_sc_hd__nand2_1_2.A a_1309_8751# sky130_fd_sc_hd__nand2_1_59.VNB sky130_fd_pr__nfet_01v8 ad=0.169 pd=1.82 as=0.08775 ps=0.92 w=0.65 l=0.15
X183 sky130_fd_sc_hd__nand2_1_52.B sky130_fd_sc_hd__inv_1_130.A vdd sky130_fd_sc_hd__nand2_1_52.VPB sky130_fd_pr__pfet_01v8_hvt ad=0.26 pd=2.52 as=0.26 ps=2.52 w=1 l=0.15
X184 vdd sky130_fd_sc_hd__nand2_1_2.B a_3981_3561# sky130_fd_sc_hd__nand2_1_28.VPB sky130_fd_pr__pfet_01v8_hvt ad=0.26 pd=2.52 as=0.105 ps=1.21 w=1 l=0.15
X185 bit0_b bit0 a_2137_8751# sky130_fd_sc_hd__nand2_1_59.VNB sky130_fd_pr__nfet_01v8 ad=0.169 pd=1.82 as=0.08775 ps=0.92 w=0.65 l=0.15
X186 sky130_fd_sc_hd__inv_1_25.A sample vss sky130_fd_sc_hd__nand2_1_59.VNB sky130_fd_pr__nfet_01v8 ad=0.08775 pd=0.92 as=0.169 ps=1.82 w=0.65 l=0.15
X187 a_109_8751# sky130_fd_sc_hd__nand2_1_2.B vss sky130_fd_sc_hd__nand2_1_59.VNB sky130_fd_pr__nfet_01v8 ad=0.08775 pd=0.92 as=0.169 ps=1.82 w=0.65 l=0.15
X188 vss sky130_fd_sc_hd__nand2_1_2.B sky130_fd_sc_hd__nand2_1_2.B sky130_fd_sc_hd__nand2_1_59.VNB sky130_fd_pr__nfet_01v8 ad=0.169 pd=1.82 as=0.08775 ps=0.92 w=0.65 l=0.15
X189 a_4537_911# sky130_fd_sc_hd__nand2_1_2.B vss sky130_fd_sc_hd__nand2_1_59.VNB sky130_fd_pr__nfet_01v8 ad=0.08775 pd=0.92 as=0.169 ps=1.82 w=0.65 l=0.15
X190 sky130_fd_sc_hd__nand2_1_18.B sky130_fd_sc_hd__inv_1_18.A vss sky130_fd_sc_hd__nand2_1_59.VNB sky130_fd_pr__nfet_01v8 ad=0.169 pd=1.82 as=0.169 ps=1.82 w=0.65 l=0.15
X191 sky130_fd_sc_hd__inv_1_36.A sky130_fd_sc_hd__inv_1_37.A vdd sky130_fd_sc_hd__nand2_1_21.VPB sky130_fd_pr__pfet_01v8_hvt ad=0.26 pd=2.52 as=0.26 ps=2.52 w=1 l=0.15
X192 sky130_fd_sc_hd__inv_1_21.A sky130_fd_sc_hd__nand2_1_2.A a_1309_5263# sky130_fd_sc_hd__nand2_1_59.VNB sky130_fd_pr__nfet_01v8 ad=0.169 pd=1.82 as=0.08775 ps=0.92 w=0.65 l=0.15
X193 a_4813_4399# sky130_fd_sc_hd__nand2_1_2.B vss sky130_fd_sc_hd__nand2_1_59.VNB sky130_fd_pr__nfet_01v8 ad=0.08775 pd=0.92 as=0.169 ps=1.82 w=0.65 l=0.15
X194 sky130_fd_sc_hd__inv_1_92.A sky130_fd_sc_hd__inv_1_93.A vdd sky130_fd_sc_hd__nand2_1_36.VPB sky130_fd_pr__pfet_01v8_hvt ad=0.26 pd=2.52 as=0.26 ps=2.52 w=1 l=0.15
X195 sky130_fd_sc_hd__nand2_1_2.B sample vdd sky130_fd_sc_hd__nand2_1_9.VPB sky130_fd_pr__pfet_01v8_hvt ad=0.26 pd=2.52 as=0.26 ps=2.52 w=1 l=0.15
X196 sky130_fd_sc_hd__inv_1_18.A sky130_fd_sc_hd__nand2_1_2.B vdd sky130_fd_sc_hd__nand2_1_15.VPB sky130_fd_pr__pfet_01v8_hvt ad=0.135 pd=1.27 as=0.26 ps=2.52 w=1 l=0.15
X197 a_2321_911# sky130_fd_sc_hd__nand2_1_55.B vss sky130_fd_sc_hd__nand2_1_59.VNB sky130_fd_pr__nfet_01v8 ad=0.08775 pd=0.92 as=0.169 ps=1.82 w=0.65 l=0.15
X198 sky130_fd_sc_hd__inv_1_113.A sky130_fd_sc_hd__nand2_1_2.B vss sky130_fd_sc_hd__nand2_1_59.VNB sky130_fd_pr__nfet_01v8 ad=0.169 pd=1.82 as=0.169 ps=1.82 w=0.65 l=0.15
X199 sky130_fd_sc_hd__nand2_1_2.B sample vss sky130_fd_sc_hd__nand2_1_59.VNB sky130_fd_pr__nfet_01v8 ad=0.169 pd=1.82 as=0.169 ps=1.82 w=0.65 l=0.15
X200 bit7_b bit7 a_2137_5263# sky130_fd_sc_hd__nand2_1_59.VNB sky130_fd_pr__nfet_01v8 ad=0.169 pd=1.82 as=0.08775 ps=0.92 w=0.65 l=0.15
X201 a_3697_297# sky130_fd_sc_hd__nand2_1_2.B sky130_fd_sc_hd__nand2_1_2.B sky130_fd_sc_hd__nand2_1_52.VPB sky130_fd_pr__pfet_01v8_hvt ad=0.105 pd=1.21 as=0.26 ps=2.52 w=1 l=0.15
X202 sky130_fd_sc_hd__inv_1_122.A sky130_fd_sc_hd__inv_1_123.A vss sky130_fd_sc_hd__nand2_1_59.VNB sky130_fd_pr__nfet_01v8 ad=0.169 pd=1.82 as=0.169 ps=1.82 w=0.65 l=0.15
X203 sky130_fd_sc_hd__inv_1_66.A sky130_fd_sc_hd__inv_1_67.A vdd sky130_fd_sc_hd__nand2_1_28.VPB sky130_fd_pr__pfet_01v8_hvt ad=0.26 pd=2.52 as=0.26 ps=2.52 w=1 l=0.15
X204 vss sky130_fd_sc_hd__nand2_1_2.B sky130_fd_sc_hd__nand2_1_2.B sky130_fd_sc_hd__nand2_1_59.VNB sky130_fd_pr__nfet_01v8 ad=0.169 pd=1.82 as=0.08775 ps=0.92 w=0.65 l=0.15
X205 sky130_fd_sc_hd__nand2_1_24.B sky130_fd_sc_hd__inv_1_24.A vdd sky130_fd_sc_hd__nand2_1_21.VPB sky130_fd_pr__pfet_01v8_hvt ad=0.26 pd=2.52 as=0.26 ps=2.52 w=1 l=0.15
X206 a_109_5263# sky130_fd_sc_hd__nand2_1_2.B vss sky130_fd_sc_hd__nand2_1_59.VNB sky130_fd_pr__nfet_01v8 ad=0.08775 pd=0.92 as=0.169 ps=1.82 w=0.65 l=0.15
X207 outn sky130_fd_sc_hd__nand2_1_2.A a_193_8527# sky130_fd_sc_hd__nand2_1_59.VNB sky130_fd_pr__nfet_01v8 ad=0.169 pd=1.82 as=0.10725 ps=0.98 w=0.65 l=0.15
X208 sky130_fd_sc_hd__inv_1_96.A sky130_fd_sc_hd__inv_1_97.A vss sky130_fd_sc_hd__nand2_1_59.VNB sky130_fd_pr__nfet_01v8 ad=0.169 pd=1.82 as=0.169 ps=1.82 w=0.65 l=0.15
X209 sky130_fd_sc_hd__nand2_1_33.B sky130_fd_sc_hd__nand2_1_2.B vdd sky130_fd_sc_hd__nand2_1_28.VPB sky130_fd_pr__pfet_01v8_hvt ad=0.26 pd=2.52 as=0.26 ps=2.52 w=1 l=0.15
X210 sky130_fd_sc_hd__nand2_1_2.B sample vdd sky130_fd_sc_hd__nand2_1_15.VPB sky130_fd_pr__pfet_01v8_hvt ad=0.26 pd=2.52 as=0.26 ps=2.52 w=1 l=0.15
X211 vdd bit0_b bit0 sky130_fd_sc_hd__nand2_1_0.VPB sky130_fd_pr__pfet_01v8_hvt ad=0.26 pd=2.52 as=0.135 ps=1.27 w=1 l=0.15
X212 sky130_fd_sc_hd__nand2_1_2.B sky130_fd_sc_hd__nand2_1_2.B vss sky130_fd_sc_hd__nand2_1_59.VNB sky130_fd_pr__nfet_01v8 ad=0.08775 pd=0.92 as=0.169 ps=1.82 w=0.65 l=0.15
X213 sky130_fd_sc_hd__nand2_1_41.B sky130_fd_sc_hd__nand2_1_2.B vss sky130_fd_sc_hd__nand2_1_59.VNB sky130_fd_pr__nfet_01v8 ad=0.169 pd=1.82 as=0.169 ps=1.82 w=0.65 l=0.15
X214 vdd sky130_fd_sc_hd__nand2_1_58.A sky130_fd_sc_hd__nand2_1_2.B sky130_fd_sc_hd__nand2_1_52.VPB sky130_fd_pr__pfet_01v8_hvt ad=0.26 pd=2.52 as=0.135 ps=1.27 w=1 l=0.15
X215 sky130_fd_sc_hd__inv_1_34.A sky130_fd_sc_hd__inv_1_35.A vss sky130_fd_sc_hd__nand2_1_59.VNB sky130_fd_pr__nfet_01v8 ad=0.169 pd=1.82 as=0.169 ps=1.82 w=0.65 l=0.15
X216 sky130_fd_sc_hd__inv_1_47.A sky130_fd_sc_hd__inv_1_48.A vdd sky130_fd_sc_hd__nand2_1_28.VPB sky130_fd_pr__pfet_01v8_hvt ad=0.26 pd=2.52 as=0.26 ps=2.52 w=1 l=0.15
X217 vdd sky130_fd_sc_hd__nand2_1_2.B a_753_8207# sky130_fd_sc_hd__nand2_1_3.VPB sky130_fd_pr__pfet_01v8_hvt ad=0.26 pd=2.52 as=0.105 ps=1.21 w=1 l=0.15
X218 vss sky130_fd_sc_hd__nand2_1_2.B sky130_fd_sc_hd__nand2_1_2.B sky130_fd_sc_hd__nand2_1_59.VNB sky130_fd_pr__nfet_01v8 ad=0.169 pd=1.82 as=0.08775 ps=0.92 w=0.65 l=0.15
X219 sky130_fd_sc_hd__nand2_1_2.B sample vss sky130_fd_sc_hd__nand2_1_59.VNB sky130_fd_pr__nfet_01v8 ad=0.169 pd=1.82 as=0.169 ps=1.82 w=0.65 l=0.15
X220 a_753_4943# sample sky130_fd_sc_hd__nand2_1_2.B sky130_fd_sc_hd__nand2_1_21.VPB sky130_fd_pr__pfet_01v8_hvt ad=0.105 pd=1.21 as=0.26 ps=2.52 w=1 l=0.15
X221 sky130_fd_sc_hd__nand2_1_2.B sample vdd sky130_fd_sc_hd__nand2_1_21.VPB sky130_fd_pr__pfet_01v8_hvt ad=0.26 pd=2.52 as=0.26 ps=2.52 w=1 l=0.15
X222 sky130_fd_sc_hd__inv_1_30.A sky130_fd_sc_hd__nand2_1_2.A vdd sky130_fd_sc_hd__nand2_1_21.VPB sky130_fd_pr__pfet_01v8_hvt ad=0.26 pd=2.52 as=0.26 ps=2.52 w=1 l=0.15
X223 sky130_fd_sc_hd__inv_1_50.A sky130_fd_sc_hd__inv_1_51.A vss sky130_fd_sc_hd__nand2_1_59.VNB sky130_fd_pr__nfet_01v8 ad=0.169 pd=1.82 as=0.169 ps=1.82 w=0.65 l=0.15
X224 sky130_fd_sc_hd__nand2_1_6.B sky130_fd_sc_hd__inv_1_6.A vdd sky130_fd_sc_hd__nand2_1_3.VPB sky130_fd_pr__pfet_01v8_hvt ad=0.26 pd=2.52 as=0.26 ps=2.52 w=1 l=0.15
X225 sky130_fd_sc_hd__nand2_1_27.B sky130_fd_sc_hd__inv_1_32.A vss sky130_fd_sc_hd__nand2_1_59.VNB sky130_fd_pr__nfet_01v8 ad=0.169 pd=1.82 as=0.169 ps=1.82 w=0.65 l=0.15
X226 sky130_fd_sc_hd__inv_1_27.A sky130_fd_sc_hd__inv_1_28.A vdd sky130_fd_sc_hd__nand2_1_21.VPB sky130_fd_pr__pfet_01v8_hvt ad=0.26 pd=2.52 as=0.26 ps=2.52 w=1 l=0.15
X227 sky130_fd_sc_hd__inv_1_155.A outp a_113_47# sky130_fd_sc_hd__nand2_1_59.VNB sky130_fd_pr__nfet_01v8 ad=0.169 pd=1.82 as=0.08775 ps=0.92 w=0.65 l=0.15
X228 bit4_b sky130_fd_sc_hd__nand2_1_12.B vdd sky130_fd_sc_hd__nand2_1_9.VPB sky130_fd_pr__pfet_01v8_hvt ad=0.135 pd=1.27 as=0.26 ps=2.52 w=1 l=0.15
X229 vss sky130_fd_sc_hd__nand2_1_2.B sky130_fd_sc_hd__nand2_1_2.B sky130_fd_sc_hd__nand2_1_59.VNB sky130_fd_pr__nfet_01v8 ad=0.169 pd=1.82 as=0.08775 ps=0.92 w=0.65 l=0.15
X230 vdd sky130_fd_sc_hd__nand2_1_32.Y sky130_fd_sc_hd__nand2_1_2.B sky130_fd_sc_hd__nand2_1_28.VPB sky130_fd_pr__pfet_01v8_hvt ad=0.26 pd=2.52 as=0.135 ps=1.27 w=1 l=0.15
X231 sky130_fd_sc_hd__inv_1_60.A sky130_fd_sc_hd__nand2_1_2.A vdd sky130_fd_sc_hd__nand2_1_28.VPB sky130_fd_pr__pfet_01v8_hvt ad=0.26 pd=2.52 as=0.26 ps=2.52 w=1 l=0.15
X232 sky130_fd_sc_hd__nand2_1_4.B sky130_fd_sc_hd__nand2_1_2.B vdd sky130_fd_sc_hd__nand2_1_3.VPB sky130_fd_pr__pfet_01v8_hvt ad=0.26 pd=2.52 as=0.26 ps=2.52 w=1 l=0.15
X233 sky130_fd_sc_hd__inv_1_90.A sky130_fd_sc_hd__nand2_1_2.A vss sky130_fd_sc_hd__nand2_1_59.VNB sky130_fd_pr__nfet_01v8 ad=0.169 pd=1.82 as=0.169 ps=1.82 w=0.65 l=0.15
X234 sky130_fd_sc_hd__nand2_1_2.B sky130_fd_sc_hd__nand2_1_40.Y a_5089_2223# sky130_fd_sc_hd__nand2_1_59.VNB sky130_fd_pr__nfet_01v8 ad=0.169 pd=1.82 as=0.08775 ps=0.92 w=0.65 l=0.15
X235 sky130_fd_sc_hd__inv_1_85.A sky130_fd_sc_hd__nand2_1_2.B vdd sky130_fd_sc_hd__nand2_1_36.VPB sky130_fd_pr__pfet_01v8_hvt ad=0.135 pd=1.27 as=0.26 ps=2.52 w=1 l=0.15
X236 sky130_fd_sc_hd__nand2_1_2.B sky130_fd_sc_hd__inv_1_58.A vdd sky130_fd_sc_hd__nand2_1_28.VPB sky130_fd_pr__pfet_01v8_hvt ad=0.26 pd=2.52 as=0.26 ps=2.52 w=1 l=0.15
X237 sky130_fd_sc_hd__nand2_1_2.A sky130_fd_sc_hd__nand2_1_2.A vdd sky130_fd_sc_hd__nand2_1_15.VPB sky130_fd_pr__pfet_01v8_hvt ad=0.26 pd=2.52 as=0.165 ps=1.33 w=1 l=0.15
X238 sky130_fd_sc_hd__inv_1_107.A sky130_fd_sc_hd__inv_1_108.A vss sky130_fd_sc_hd__nand2_1_59.VNB sky130_fd_pr__nfet_01v8 ad=0.169 pd=1.82 as=0.169 ps=1.82 w=0.65 l=0.15
X239 sky130_fd_sc_hd__inv_1_149.A sky130_fd_sc_hd__inv_1_150.A vss sky130_fd_sc_hd__nand2_1_59.VNB sky130_fd_pr__nfet_01v8 ad=0.169 pd=1.82 as=0.169 ps=1.82 w=0.65 l=0.15
X240 a_4537_1135# sky130_fd_sc_hd__nand2_1_2.B vss sky130_fd_sc_hd__nand2_1_59.VNB sky130_fd_pr__nfet_01v8 ad=0.08775 pd=0.92 as=0.169 ps=1.82 w=0.65 l=0.15
X241 sky130_fd_sc_hd__nand2_1_2.B sky130_fd_sc_hd__inv_1_88.A vss sky130_fd_sc_hd__nand2_1_59.VNB sky130_fd_pr__nfet_01v8 ad=0.169 pd=1.82 as=0.169 ps=1.82 w=0.65 l=0.15
X242 a_3421_297# sky130_fd_sc_hd__nand2_1_2.B sky130_fd_sc_hd__nand2_1_2.B sky130_fd_sc_hd__nand2_1_52.VPB sky130_fd_pr__pfet_01v8_hvt ad=0.105 pd=1.21 as=0.26 ps=2.52 w=1 l=0.15
X243 sky130_fd_sc_hd__inv_1_143.A sky130_fd_sc_hd__nand2_1_2.B vss sky130_fd_sc_hd__nand2_1_59.VNB sky130_fd_pr__nfet_01v8 ad=0.169 pd=1.82 as=0.169 ps=1.82 w=0.65 l=0.15
X244 sky130_fd_sc_hd__nand2_1_40.Y sky130_fd_sc_hd__nand2_1_40.B vdd sky130_fd_sc_hd__nand2_1_36.VPB sky130_fd_pr__pfet_01v8_hvt ad=0.135 pd=1.27 as=0.26 ps=2.52 w=1 l=0.15
X245 a_193_5487# outn a_109_5487# sky130_fd_sc_hd__nand2_1_59.VNB sky130_fd_pr__nfet_01v8 ad=0.10725 pd=0.98 as=0.08775 ps=0.92 w=0.65 l=0.15
X246 sky130_fd_sc_hd__nand2_1_28.Y sky130_fd_sc_hd__nand2_1_2.B a_5365_4175# sky130_fd_sc_hd__nand2_1_59.VNB sky130_fd_pr__nfet_01v8 ad=0.169 pd=1.82 as=0.08775 ps=0.92 w=0.65 l=0.15
X247 sky130_fd_sc_hd__nand2_1_1.B sky130_fd_sc_hd__nand2_1_2.B vss sky130_fd_sc_hd__nand2_1_59.VNB sky130_fd_pr__nfet_01v8 ad=0.169 pd=1.82 as=0.169 ps=1.82 w=0.65 l=0.15
X248 a_5365_1135# sky130_fd_sc_hd__nand2_1_48.B vss sky130_fd_sc_hd__nand2_1_59.VNB sky130_fd_pr__nfet_01v8 ad=0.08775 pd=0.92 as=0.169 ps=1.82 w=0.65 l=0.15
X249 bit4 sky130_fd_sc_hd__nand2_1_13.B vdd sky130_fd_sc_hd__nand2_1_9.VPB sky130_fd_pr__pfet_01v8_hvt ad=0.135 pd=1.27 as=0.26 ps=2.52 w=1 l=0.15
X250 sky130_fd_sc_hd__nand2_1_2.B sample vdd sky130_fd_sc_hd__nand2_1_44.VPB sky130_fd_pr__pfet_01v8_hvt ad=0.26 pd=2.52 as=0.26 ps=2.52 w=1 l=0.15
X251 bit1 bit1_b a_1861_8527# sky130_fd_sc_hd__nand2_1_59.VNB sky130_fd_pr__nfet_01v8 ad=0.169 pd=1.82 as=0.08775 ps=0.92 w=0.65 l=0.15
X252 sky130_fd_sc_hd__inv_1_9.A sky130_fd_sc_hd__nand2_1_2.B vdd sky130_fd_sc_hd__nand2_1_9.VPB sky130_fd_pr__pfet_01v8_hvt ad=0.135 pd=1.27 as=0.26 ps=2.52 w=1 l=0.15
X253 sky130_fd_sc_hd__inv_1_150.A sky130_fd_sc_hd__inv_1_151.A vdd sky130_fd_sc_hd__nand2_1_52.VPB sky130_fd_pr__pfet_01v8_hvt ad=0.26 pd=2.52 as=0.26 ps=2.52 w=1 l=0.15
X254 sky130_fd_sc_hd__inv_1_125.A sky130_fd_sc_hd__inv_1_126.A vdd sky130_fd_sc_hd__nand2_1_44.VPB sky130_fd_pr__pfet_01v8_hvt ad=0.26 pd=2.52 as=0.26 ps=2.52 w=1 l=0.15
X255 sky130_fd_sc_hd__nand2_1_2.A sky130_fd_sc_hd__nand2_1_27.B vdd sky130_fd_sc_hd__nand2_1_21.VPB sky130_fd_pr__pfet_01v8_hvt ad=0.135 pd=1.27 as=0.26 ps=2.52 w=1 l=0.15
X256 a_113_47# outn vss sky130_fd_sc_hd__nand2_1_59.VNB sky130_fd_pr__nfet_01v8 ad=0.08775 pd=0.92 as=0.169 ps=1.82 w=0.65 l=0.15
X257 sky130_fd_sc_hd__inv_1_40.A sky130_fd_sc_hd__nand2_1_2.B vdd sky130_fd_sc_hd__nand2_1_28.VPB sky130_fd_pr__pfet_01v8_hvt ad=0.135 pd=1.27 as=0.26 ps=2.52 w=1 l=0.15
X258 sky130_fd_sc_hd__inv_1_145.A sky130_fd_sc_hd__nand2_1_2.B vss sky130_fd_sc_hd__nand2_1_59.VNB sky130_fd_pr__nfet_01v8 ad=0.08775 pd=0.92 as=0.169 ps=1.82 w=0.65 l=0.15
X259 sky130_fd_sc_hd__nand2_1_28.Y sky130_fd_sc_hd__nand2_1_28.B vdd sky130_fd_sc_hd__nand2_1_28.VPB sky130_fd_pr__pfet_01v8_hvt ad=0.135 pd=1.27 as=0.26 ps=2.52 w=1 l=0.15
X260 sky130_fd_sc_hd__nand2_1_2.B sample vss sky130_fd_sc_hd__nand2_1_59.VNB sky130_fd_pr__nfet_01v8 ad=0.08775 pd=0.92 as=0.169 ps=1.82 w=0.65 l=0.15
X261 sky130_fd_sc_hd__inv_1_15.A sky130_fd_sc_hd__nand2_1_2.B vdd sky130_fd_sc_hd__nand2_1_15.VPB sky130_fd_pr__pfet_01v8_hvt ad=0.135 pd=1.27 as=0.26 ps=2.52 w=1 l=0.15
X262 sky130_fd_sc_hd__nand2_1_22.B sky130_fd_sc_hd__nand2_1_2.B vss sky130_fd_sc_hd__nand2_1_59.VNB sky130_fd_pr__nfet_01v8 ad=0.169 pd=1.82 as=0.169 ps=1.82 w=0.65 l=0.15
X263 sky130_fd_sc_hd__nand2_1_32.B sky130_fd_sc_hd__inv_1_55.A vss sky130_fd_sc_hd__nand2_1_59.VNB sky130_fd_pr__nfet_01v8 ad=0.169 pd=1.82 as=0.169 ps=1.82 w=0.65 l=0.15
X264 sky130_fd_sc_hd__nand2_1_2.A sky130_fd_sc_hd__nand2_1_35.B vdd sky130_fd_sc_hd__nand2_1_28.VPB sky130_fd_pr__pfet_01v8_hvt ad=0.135 pd=1.27 as=0.26 ps=2.52 w=1 l=0.15
X265 a_2321_2223# sky130_fd_sc_hd__nand2_1_43.B vss sky130_fd_sc_hd__nand2_1_59.VNB sky130_fd_pr__nfet_01v8 ad=0.08775 pd=0.92 as=0.169 ps=1.82 w=0.65 l=0.15
X266 sky130_fd_sc_hd__inv_1_80.A sky130_fd_sc_hd__inv_1_81.A vdd sky130_fd_sc_hd__nand2_1_36.VPB sky130_fd_pr__pfet_01v8_hvt ad=0.26 pd=2.52 as=0.26 ps=2.52 w=1 l=0.15
X267 a_1309_7663# sky130_fd_sc_hd__nand2_1_2.B vss sky130_fd_sc_hd__nand2_1_59.VNB sky130_fd_pr__nfet_01v8 ad=0.08775 pd=0.92 as=0.169 ps=1.82 w=0.65 l=0.15
X268 sky130_fd_sc_hd__inv_1_154.A sky130_fd_sc_hd__inv_1_155.A vss sky130_fd_sc_hd__nand2_1_59.VNB sky130_fd_pr__nfet_01v8 ad=0.169 pd=1.82 as=0.169 ps=1.82 w=0.65 l=0.15
X269 sky130_fd_sc_hd__inv_1_37.A sky130_fd_sc_hd__inv_1_38.A vdd sky130_fd_sc_hd__nand2_1_21.VPB sky130_fd_pr__pfet_01v8_hvt ad=0.26 pd=2.52 as=0.26 ps=2.52 w=1 l=0.15
X270 vdd outn sky130_fd_sc_hd__nand2_1_2.A sky130_fd_sc_hd__nand2_1_3.VPB sky130_fd_pr__pfet_01v8_hvt ad=0.165 pd=1.33 as=0.135 ps=1.27 w=1 l=0.15
X271 a_4537_1999# sky130_fd_sc_hd__nand2_1_2.B vss sky130_fd_sc_hd__nand2_1_59.VNB sky130_fd_pr__nfet_01v8 ad=0.08775 pd=0.92 as=0.169 ps=1.82 w=0.65 l=0.15
X272 vdd sky130_fd_sc_hd__nand2_1_2.B sky130_fd_sc_hd__nand2_1_48.Y sky130_fd_sc_hd__nand2_1_44.VPB sky130_fd_pr__pfet_01v8_hvt ad=0.26 pd=2.52 as=0.135 ps=1.27 w=1 l=0.15
X273 sky130_fd_sc_hd__inv_1_138.A sky130_fd_sc_hd__inv_1_139.A vdd sky130_fd_sc_hd__nand2_1_52.VPB sky130_fd_pr__pfet_01v8_hvt ad=0.26 pd=2.52 as=0.26 ps=2.52 w=1 l=0.15
X274 sky130_fd_sc_hd__inv_1_81.A sky130_fd_sc_hd__inv_1_82.A vss sky130_fd_sc_hd__nand2_1_59.VNB sky130_fd_pr__nfet_01v8 ad=0.169 pd=1.82 as=0.169 ps=1.82 w=0.65 l=0.15
X275 bit1_b sky130_fd_sc_hd__nand2_1_3.B vdd sky130_fd_sc_hd__nand2_1_3.VPB sky130_fd_pr__pfet_01v8_hvt ad=0.135 pd=1.27 as=0.26 ps=2.52 w=1 l=0.15
X276 sky130_fd_sc_hd__inv_1_67.A sky130_fd_sc_hd__inv_1_68.A vdd sky130_fd_sc_hd__nand2_1_28.VPB sky130_fd_pr__pfet_01v8_hvt ad=0.26 pd=2.52 as=0.26 ps=2.52 w=1 l=0.15
X277 a_5365_1999# sky130_fd_sc_hd__nand2_1_44.B vss sky130_fd_sc_hd__nand2_1_59.VNB sky130_fd_pr__nfet_01v8 ad=0.08775 pd=0.92 as=0.169 ps=1.82 w=0.65 l=0.15
X278 sky130_fd_sc_hd__inv_1_93.A sky130_fd_sc_hd__inv_1_94.A vdd sky130_fd_sc_hd__nand2_1_36.VPB sky130_fd_pr__pfet_01v8_hvt ad=0.26 pd=2.52 as=0.26 ps=2.52 w=1 l=0.15
X279 vdd bit6_b bit6 sky130_fd_sc_hd__nand2_1_15.VPB sky130_fd_pr__pfet_01v8_hvt ad=0.26 pd=2.52 as=0.135 ps=1.27 w=1 l=0.15
X280 vdd sky130_fd_sc_hd__nand2_1_2.B a_4249_297# sky130_fd_sc_hd__nand2_1_52.VPB sky130_fd_pr__pfet_01v8_hvt ad=0.26 pd=2.52 as=0.105 ps=1.21 w=1 l=0.15
X281 sky130_fd_sc_hd__nand2_1_2.A sky130_fd_sc_hd__inv_1_154.A vss sky130_fd_sc_hd__nand2_1_59.VNB sky130_fd_pr__nfet_01v8 ad=0.169 pd=1.82 as=0.169 ps=1.82 w=0.65 l=0.15
X282 sky130_fd_sc_hd__nand2_1_37.B sky130_fd_sc_hd__nand2_1_2.B vss sky130_fd_sc_hd__nand2_1_59.VNB sky130_fd_pr__nfet_01v8 ad=0.169 pd=1.82 as=0.169 ps=1.82 w=0.65 l=0.15
X283 sky130_fd_sc_hd__inv_1_97.A sky130_fd_sc_hd__inv_1_98.A vss sky130_fd_sc_hd__nand2_1_59.VNB sky130_fd_pr__nfet_01v8 ad=0.169 pd=1.82 as=0.169 ps=1.82 w=0.65 l=0.15
X284 sky130_fd_sc_hd__inv_1_18.A sky130_fd_sc_hd__nand2_1_2.A a_1309_5487# sky130_fd_sc_hd__nand2_1_59.VNB sky130_fd_pr__nfet_01v8 ad=0.169 pd=1.82 as=0.08775 ps=0.92 w=0.65 l=0.15
X285 sky130_fd_sc_hd__inv_1_123.A sky130_fd_sc_hd__inv_1_124.A vss sky130_fd_sc_hd__nand2_1_59.VNB sky130_fd_pr__nfet_01v8 ad=0.169 pd=1.82 as=0.169 ps=1.82 w=0.65 l=0.15
X286 outn sky130_fd_sc_hd__nand2_1_2.A vdd sky130_fd_sc_hd__nand2_1_9.VPB sky130_fd_pr__pfet_01v8_hvt ad=0.26 pd=2.52 as=0.165 ps=1.33 w=1 l=0.15
X287 bit6_b bit6 a_2137_5487# sky130_fd_sc_hd__nand2_1_59.VNB sky130_fd_pr__nfet_01v8 ad=0.169 pd=1.82 as=0.08775 ps=0.92 w=0.65 l=0.15
X288 vdd sky130_fd_sc_hd__nand2_1_2.B sky130_fd_sc_hd__nand2_1_36.Y sky130_fd_sc_hd__nand2_1_36.VPB sky130_fd_pr__pfet_01v8_hvt ad=0.26 pd=2.52 as=0.135 ps=1.27 w=1 l=0.15
X289 sky130_fd_sc_hd__nand2_1_2.B sky130_fd_sc_hd__nand2_1_58.B vdd sky130_fd_sc_hd__nand2_1_52.VPB sky130_fd_pr__pfet_01v8_hvt ad=0.135 pd=1.27 as=0.26 ps=2.52 w=1 l=0.15
X290 sky130_fd_sc_hd__nand2_1_9.B sky130_fd_sc_hd__inv_1_9.A vss sky130_fd_sc_hd__nand2_1_59.VNB sky130_fd_pr__nfet_01v8 ad=0.169 pd=1.82 as=0.169 ps=1.82 w=0.65 l=0.15
X291 vss sky130_fd_sc_hd__nand2_1_2.B sky130_fd_sc_hd__nand2_1_2.B sky130_fd_sc_hd__nand2_1_59.VNB sky130_fd_pr__nfet_01v8 ad=0.169 pd=1.82 as=0.08775 ps=0.92 w=0.65 l=0.15
X292 a_109_5487# sky130_fd_sc_hd__nand2_1_2.B vss sky130_fd_sc_hd__nand2_1_59.VNB sky130_fd_pr__nfet_01v8 ad=0.08775 pd=0.92 as=0.169 ps=1.82 w=0.65 l=0.15
X293 vdd sky130_fd_sc_hd__nand2_1_2.A sky130_fd_sc_hd__nand2_1_2.A sky130_fd_sc_hd__nand2_1_36.VPB sky130_fd_pr__pfet_01v8_hvt ad=0.26 pd=2.52 as=0.135 ps=1.27 w=1 l=0.15
X294 sky130_fd_sc_hd__inv_1_48.A sky130_fd_sc_hd__inv_1_49.A vdd sky130_fd_sc_hd__nand2_1_28.VPB sky130_fd_pr__pfet_01v8_hvt ad=0.26 pd=2.52 as=0.26 ps=2.52 w=1 l=0.15
X295 a_2137_8751# sky130_fd_sc_hd__nand2_1_0.B vss sky130_fd_sc_hd__nand2_1_59.VNB sky130_fd_pr__nfet_01v8 ad=0.08775 pd=0.92 as=0.169 ps=1.82 w=0.65 l=0.15
X296 bit1 sky130_fd_sc_hd__nand2_1_4.B vdd sky130_fd_sc_hd__nand2_1_3.VPB sky130_fd_pr__pfet_01v8_hvt ad=0.135 pd=1.27 as=0.26 ps=2.52 w=1 l=0.15
X297 sky130_fd_sc_hd__nand2_1_2.B sky130_fd_sc_hd__nand2_1_2.A vdd sky130_fd_sc_hd__nand2_1_15.VPB sky130_fd_pr__pfet_01v8_hvt ad=0.26 pd=2.52 as=0.165 ps=1.33 w=1 l=0.15
X298 sky130_fd_sc_hd__inv_1_28.A sky130_fd_sc_hd__inv_1_29.A vdd sky130_fd_sc_hd__nand2_1_21.VPB sky130_fd_pr__pfet_01v8_hvt ad=0.26 pd=2.52 as=0.26 ps=2.52 w=1 l=0.15
X299 sky130_fd_sc_hd__nand2_1_2.A sky130_fd_sc_hd__nand2_1_2.A a_2321_1135# sky130_fd_sc_hd__nand2_1_59.VNB sky130_fd_pr__nfet_01v8 ad=0.169 pd=1.82 as=0.08775 ps=0.92 w=0.65 l=0.15
X300 sky130_fd_sc_hd__nand2_1_52.Y sky130_fd_sc_hd__nand2_1_2.B a_5365_911# sky130_fd_sc_hd__nand2_1_59.VNB sky130_fd_pr__nfet_01v8 ad=0.169 pd=1.82 as=0.08775 ps=0.92 w=0.65 l=0.15
X301 vdd sky130_fd_sc_hd__nand2_1_2.B a_3981_1679# sky130_fd_sc_hd__nand2_1_44.VPB sky130_fd_pr__pfet_01v8_hvt ad=0.26 pd=2.52 as=0.105 ps=1.21 w=1 l=0.15
X302 sky130_fd_sc_hd__nand2_1_2.B sky130_fd_sc_hd__nand2_1_36.Y a_5089_3087# sky130_fd_sc_hd__nand2_1_59.VNB sky130_fd_pr__nfet_01v8 ad=0.169 pd=1.82 as=0.08775 ps=0.92 w=0.65 l=0.15
X303 sky130_fd_sc_hd__inv_1_75.A sky130_fd_sc_hd__nand2_1_2.A vss sky130_fd_sc_hd__nand2_1_59.VNB sky130_fd_pr__nfet_01v8 ad=0.169 pd=1.82 as=0.169 ps=1.82 w=0.65 l=0.15
X304 sky130_fd_sc_hd__nand2_1_15.B sky130_fd_sc_hd__inv_1_15.A vss sky130_fd_sc_hd__nand2_1_59.VNB sky130_fd_pr__nfet_01v8 ad=0.169 pd=1.82 as=0.169 ps=1.82 w=0.65 l=0.15
X305 sky130_fd_sc_hd__inv_1_137.A sky130_fd_sc_hd__inv_1_138.A vss sky130_fd_sc_hd__nand2_1_59.VNB sky130_fd_pr__nfet_01v8 ad=0.169 pd=1.82 as=0.169 ps=1.82 w=0.65 l=0.15
X306 sky130_fd_sc_hd__nand2_1_2.A sky130_fd_sc_hd__nand2_1_2.A a_193_7663# sky130_fd_sc_hd__nand2_1_59.VNB sky130_fd_pr__nfet_01v8 ad=0.169 pd=1.82 as=0.10725 ps=0.98 w=0.65 l=0.15
X307 sky130_fd_sc_hd__nand2_1_2.B sky130_fd_sc_hd__inv_1_73.A vss sky130_fd_sc_hd__nand2_1_59.VNB sky130_fd_pr__nfet_01v8 ad=0.169 pd=1.82 as=0.169 ps=1.82 w=0.65 l=0.15
X308 sky130_fd_sc_hd__inv_1_35.A sky130_fd_sc_hd__inv_1_36.A vss sky130_fd_sc_hd__nand2_1_59.VNB sky130_fd_pr__nfet_01v8 ad=0.169 pd=1.82 as=0.169 ps=1.82 w=0.65 l=0.15
X309 sky130_fd_sc_hd__inv_1_58.A sky130_fd_sc_hd__inv_1_59.A vdd sky130_fd_sc_hd__nand2_1_28.VPB sky130_fd_pr__pfet_01v8_hvt ad=0.26 pd=2.52 as=0.26 ps=2.52 w=1 l=0.15
X310 vdd sky130_fd_sc_hd__nand2_1_2.A sky130_fd_sc_hd__inv_1_6.A sky130_fd_sc_hd__nand2_1_3.VPB sky130_fd_pr__pfet_01v8_hvt ad=0.26 pd=2.52 as=0.135 ps=1.27 w=1 l=0.15
X311 vdd sky130_fd_sc_hd__nand2_1_2.A sky130_fd_sc_hd__nand2_1_2.A sky130_fd_sc_hd__nand2_1_28.VPB sky130_fd_pr__pfet_01v8_hvt ad=0.26 pd=2.52 as=0.135 ps=1.27 w=1 l=0.15
X312 a_2137_5263# sky130_fd_sc_hd__nand2_1_21.B vss sky130_fd_sc_hd__nand2_1_59.VNB sky130_fd_pr__nfet_01v8 ad=0.08775 pd=0.92 as=0.169 ps=1.82 w=0.65 l=0.15
X313 sky130_fd_sc_hd__inv_1_88.A sky130_fd_sc_hd__inv_1_89.A vss sky130_fd_sc_hd__nand2_1_59.VNB sky130_fd_pr__nfet_01v8 ad=0.169 pd=1.82 as=0.169 ps=1.82 w=0.65 l=0.15
X314 a_1861_8751# sky130_fd_sc_hd__nand2_1_1.B vss sky130_fd_sc_hd__nand2_1_59.VNB sky130_fd_pr__nfet_01v8 ad=0.08775 pd=0.92 as=0.169 ps=1.82 w=0.65 l=0.15
X315 sky130_fd_sc_hd__nand2_1_2.B sky130_fd_sc_hd__nand2_1_41.B vdd sky130_fd_sc_hd__nand2_1_36.VPB sky130_fd_pr__pfet_01v8_hvt ad=0.135 pd=1.27 as=0.26 ps=2.52 w=1 l=0.15
X316 vdd bit2 bit2_b sky130_fd_sc_hd__nand2_1_3.VPB sky130_fd_pr__pfet_01v8_hvt ad=0.26 pd=2.52 as=0.135 ps=1.27 w=1 l=0.15
X317 sky130_fd_sc_hd__inv_1_29.A sky130_fd_sc_hd__inv_1_30.A vdd sky130_fd_sc_hd__nand2_1_21.VPB sky130_fd_pr__pfet_01v8_hvt ad=0.26 pd=2.52 as=0.26 ps=2.52 w=1 l=0.15
X318 sky130_fd_sc_hd__nand2_1_2.B sky130_fd_sc_hd__nand2_1_2.B vdd sky130_fd_sc_hd__nand2_1_52.VPB sky130_fd_pr__pfet_01v8_hvt ad=0.26 pd=2.52 as=0.26 ps=2.52 w=1 l=0.15
X319 sky130_fd_sc_hd__inv_1_108.A sky130_fd_sc_hd__inv_1_109.A vss sky130_fd_sc_hd__nand2_1_59.VNB sky130_fd_pr__nfet_01v8 ad=0.169 pd=1.82 as=0.169 ps=1.82 w=0.65 l=0.15
X320 vss sky130_fd_sc_hd__nand2_1_2.B sky130_fd_sc_hd__nand2_1_2.B sky130_fd_sc_hd__nand2_1_59.VNB sky130_fd_pr__nfet_01v8 ad=0.169 pd=1.82 as=0.08775 ps=0.92 w=0.65 l=0.15
X321 sky130_fd_sc_hd__inv_1_151.A sky130_fd_sc_hd__nand2_1_58.A vdd sky130_fd_sc_hd__nand2_1_52.VPB sky130_fd_pr__pfet_01v8_hvt ad=0.26 pd=2.52 as=0.26 ps=2.52 w=1 l=0.15
X322 a_753_9001# sample sky130_fd_sc_hd__nand2_1_2.B sky130_fd_sc_hd__nand2_1_0.VPB sky130_fd_pr__pfet_01v8_hvt ad=0.105 pd=1.21 as=0.26 ps=2.52 w=1 l=0.15
X323 sky130_fd_sc_hd__nand2_1_2.A sky130_fd_sc_hd__nand2_1_2.B vdd sky130_fd_sc_hd__nand2_1_3.VPB sky130_fd_pr__pfet_01v8_hvt ad=0.135 pd=1.27 as=0.26 ps=2.52 w=1 l=0.15
X324 a_5089_1135# sky130_fd_sc_hd__nand2_1_2.B vss sky130_fd_sc_hd__nand2_1_59.VNB sky130_fd_pr__nfet_01v8 ad=0.08775 pd=0.92 as=0.169 ps=1.82 w=0.65 l=0.15
X325 vdd sky130_fd_sc_hd__nand2_1_2.A sky130_fd_sc_hd__inv_1_55.A sky130_fd_sc_hd__nand2_1_28.VPB sky130_fd_pr__pfet_01v8_hvt ad=0.26 pd=2.52 as=0.135 ps=1.27 w=1 l=0.15
X326 a_4529_47# sky130_fd_sc_hd__nand2_1_2.B vss sky130_fd_sc_hd__nand2_1_59.VNB sky130_fd_pr__nfet_01v8 ad=0.08775 pd=0.92 as=0.169 ps=1.82 w=0.65 l=0.15
X327 sky130_fd_sc_hd__inv_1_111.A sky130_fd_sc_hd__inv_1_112.A vdd sky130_fd_sc_hd__nand2_1_44.VPB sky130_fd_pr__pfet_01v8_hvt ad=0.26 pd=2.52 as=0.26 ps=2.52 w=1 l=0.15
X328 sky130_fd_sc_hd__nand2_1_45.B sky130_fd_sc_hd__nand2_1_2.B vdd sky130_fd_sc_hd__nand2_1_44.VPB sky130_fd_pr__pfet_01v8_hvt ad=0.26 pd=2.52 as=0.26 ps=2.52 w=1 l=0.15
X329 sky130_fd_sc_hd__inv_1_85.A sky130_fd_sc_hd__nand2_1_2.A a_4537_2223# sky130_fd_sc_hd__nand2_1_59.VNB sky130_fd_pr__nfet_01v8 ad=0.169 pd=1.82 as=0.08775 ps=0.92 w=0.65 l=0.15
X330 sky130_fd_sc_hd__inv_1_59.A sky130_fd_sc_hd__inv_1_60.A vdd sky130_fd_sc_hd__nand2_1_28.VPB sky130_fd_pr__pfet_01v8_hvt ad=0.26 pd=2.52 as=0.26 ps=2.52 w=1 l=0.15
X331 sky130_fd_sc_hd__nand2_1_28.B sky130_fd_sc_hd__inv_1_40.A vss sky130_fd_sc_hd__nand2_1_59.VNB sky130_fd_pr__nfet_01v8 ad=0.169 pd=1.82 as=0.169 ps=1.82 w=0.65 l=0.15
X332 sky130_fd_sc_hd__nand2_1_2.B sample vss sky130_fd_sc_hd__nand2_1_59.VNB sky130_fd_pr__nfet_01v8 ad=0.169 pd=1.82 as=0.169 ps=1.82 w=0.65 l=0.15
X333 a_1861_5263# sky130_fd_sc_hd__nand2_1_22.B vss sky130_fd_sc_hd__nand2_1_59.VNB sky130_fd_pr__nfet_01v8 ad=0.08775 pd=0.92 as=0.169 ps=1.82 w=0.65 l=0.15
X334 sky130_fd_sc_hd__nand2_1_58.A sample vdd sky130_fd_sc_hd__nand2_1_52.VPB sky130_fd_pr__pfet_01v8_hvt ad=0.26 pd=2.52 as=0.26 ps=2.52 w=1 l=0.15
X335 vdd bit3_b bit3 sky130_fd_sc_hd__nand2_1_9.VPB sky130_fd_pr__pfet_01v8_hvt ad=0.26 pd=2.52 as=0.135 ps=1.27 w=1 l=0.15
X336 sky130_fd_sc_hd__nand2_1_2.B sky130_fd_sc_hd__nand2_1_29.B vdd sky130_fd_sc_hd__nand2_1_28.VPB sky130_fd_pr__pfet_01v8_hvt ad=0.135 pd=1.27 as=0.26 ps=2.52 w=1 l=0.15
X337 sky130_fd_sc_hd__nand2_1_2.B sky130_fd_sc_hd__nand2_1_24.Y a_5365_4399# sky130_fd_sc_hd__nand2_1_59.VNB sky130_fd_pr__nfet_01v8 ad=0.169 pd=1.82 as=0.08775 ps=0.92 w=0.65 l=0.15
X338 sky130_fd_sc_hd__nand2_1_2.A sky130_fd_sc_hd__nand2_1_2.A a_2321_1999# sky130_fd_sc_hd__nand2_1_59.VNB sky130_fd_pr__nfet_01v8 ad=0.169 pd=1.82 as=0.08775 ps=0.92 w=0.65 l=0.15
X339 sky130_fd_sc_hd__inv_1_89.A sky130_fd_sc_hd__inv_1_90.A vss sky130_fd_sc_hd__nand2_1_59.VNB sky130_fd_pr__nfet_01v8 ad=0.169 pd=1.82 as=0.169 ps=1.82 w=0.65 l=0.15
X340 a_2321_3087# sky130_fd_sc_hd__nand2_1_39.B vss sky130_fd_sc_hd__nand2_1_59.VNB sky130_fd_pr__nfet_01v8 ad=0.08775 pd=0.92 as=0.169 ps=1.82 w=0.65 l=0.15
X341 a_4805_47# sky130_fd_sc_hd__nand2_1_2.B vss sky130_fd_sc_hd__nand2_1_59.VNB sky130_fd_pr__nfet_01v8 ad=0.08775 pd=0.92 as=0.169 ps=1.82 w=0.65 l=0.15
X342 done sky130_fd_sc_hd__inv_1_27.A vss sky130_fd_sc_hd__nand2_1_59.VNB sky130_fd_pr__nfet_01v8 ad=0.169 pd=1.82 as=0.169 ps=1.82 w=0.65 l=0.15
X343 sky130_fd_sc_hd__nand2_1_2.B sample vss sky130_fd_sc_hd__nand2_1_59.VNB sky130_fd_pr__nfet_01v8 ad=0.169 pd=1.82 as=0.169 ps=1.82 w=0.65 l=0.15
X344 vdd bit5_b bit5 sky130_fd_sc_hd__nand2_1_15.VPB sky130_fd_pr__pfet_01v8_hvt ad=0.26 pd=2.52 as=0.135 ps=1.27 w=1 l=0.15
X345 sky130_fd_sc_hd__nand2_1_2.B sky130_fd_sc_hd__nand2_1_52.Y a_5089_911# sky130_fd_sc_hd__nand2_1_59.VNB sky130_fd_pr__nfet_01v8 ad=0.169 pd=1.82 as=0.08775 ps=0.92 w=0.65 l=0.15
X346 a_193_7439# outn a_109_7439# sky130_fd_sc_hd__nand2_1_59.VNB sky130_fd_pr__nfet_01v8 ad=0.10725 pd=0.98 as=0.08775 ps=0.92 w=0.65 l=0.15
X347 sky130_fd_sc_hd__inv_1_139.A sky130_fd_sc_hd__inv_1_140.A vdd sky130_fd_sc_hd__nand2_1_52.VPB sky130_fd_pr__pfet_01v8_hvt ad=0.26 pd=2.52 as=0.26 ps=2.52 w=1 l=0.15
X348 a_3981_2473# sample sky130_fd_sc_hd__nand2_1_2.B sky130_fd_sc_hd__nand2_1_36.VPB sky130_fd_pr__pfet_01v8_hvt ad=0.105 pd=1.21 as=0.26 ps=2.52 w=1 l=0.15
X349 sky130_fd_sc_hd__nand2_1_2.B sample vdd sky130_fd_sc_hd__nand2_1_9.VPB sky130_fd_pr__pfet_01v8_hvt ad=0.26 pd=2.52 as=0.26 ps=2.52 w=1 l=0.15
X350 sky130_fd_sc_hd__inv_1_105.A sky130_fd_sc_hd__nand2_1_2.A vdd sky130_fd_sc_hd__nand2_1_44.VPB sky130_fd_pr__pfet_01v8_hvt ad=0.26 pd=2.52 as=0.26 ps=2.52 w=1 l=0.15
X351 bit2 bit2_b a_1861_7663# sky130_fd_sc_hd__nand2_1_59.VNB sky130_fd_pr__nfet_01v8 ad=0.169 pd=1.82 as=0.08775 ps=0.92 w=0.65 l=0.15
X352 sky130_fd_sc_hd__nand2_1_19.B sky130_fd_sc_hd__nand2_1_2.B vss sky130_fd_sc_hd__nand2_1_59.VNB sky130_fd_pr__nfet_01v8 ad=0.169 pd=1.82 as=0.169 ps=1.82 w=0.65 l=0.15
X353 sky130_fd_sc_hd__inv_1_38.A sky130_fd_sc_hd__nand2_1_2.B vdd sky130_fd_sc_hd__nand2_1_21.VPB sky130_fd_pr__pfet_01v8_hvt ad=0.26 pd=2.52 as=0.26 ps=2.52 w=1 l=0.15
X354 sky130_fd_sc_hd__nand2_1_2.B sample vss sky130_fd_sc_hd__nand2_1_59.VNB sky130_fd_pr__nfet_01v8 ad=0.08775 pd=0.92 as=0.169 ps=1.82 w=0.65 l=0.15
X355 vdd sky130_fd_sc_hd__nand2_1_44.Y sky130_fd_sc_hd__nand2_1_2.B sky130_fd_sc_hd__nand2_1_44.VPB sky130_fd_pr__pfet_01v8_hvt ad=0.26 pd=2.52 as=0.135 ps=1.27 w=1 l=0.15
X356 sky130_fd_sc_hd__nand2_1_21.B sky130_fd_sc_hd__inv_1_21.A vdd sky130_fd_sc_hd__nand2_1_21.VPB sky130_fd_pr__pfet_01v8_hvt ad=0.26 pd=2.52 as=0.26 ps=2.52 w=1 l=0.15
X357 sky130_fd_sc_hd__inv_1_82.A sky130_fd_sc_hd__inv_1_83.A vss sky130_fd_sc_hd__nand2_1_59.VNB sky130_fd_pr__nfet_01v8 ad=0.169 pd=1.82 as=0.169 ps=1.82 w=0.65 l=0.15
X358 a_193_6351# outn a_109_6351# sky130_fd_sc_hd__nand2_1_59.VNB sky130_fd_pr__nfet_01v8 ad=0.10725 pd=0.98 as=0.08775 ps=0.92 w=0.65 l=0.15
X359 a_5365_911# sky130_fd_sc_hd__nand2_1_52.B vss sky130_fd_sc_hd__nand2_1_59.VNB sky130_fd_pr__nfet_01v8 ad=0.08775 pd=0.92 as=0.169 ps=1.82 w=0.65 l=0.15
X360 sky130_fd_sc_hd__inv_1_94.A sky130_fd_sc_hd__inv_1_95.A vdd sky130_fd_sc_hd__nand2_1_36.VPB sky130_fd_pr__pfet_01v8_hvt ad=0.26 pd=2.52 as=0.26 ps=2.52 w=1 l=0.15
X361 sky130_fd_sc_hd__nand2_1_24.Y sky130_fd_sc_hd__nand2_1_24.B vdd sky130_fd_sc_hd__nand2_1_21.VPB sky130_fd_pr__pfet_01v8_hvt ad=0.135 pd=1.27 as=0.26 ps=2.52 w=1 l=0.15
X362 sky130_fd_sc_hd__nand2_1_2.B sky130_fd_sc_hd__inv_1_103.A vdd sky130_fd_sc_hd__nand2_1_44.VPB sky130_fd_pr__pfet_01v8_hvt ad=0.26 pd=2.52 as=0.26 ps=2.52 w=1 l=0.15
X363 a_5089_1999# sky130_fd_sc_hd__nand2_1_45.B vss sky130_fd_sc_hd__nand2_1_59.VNB sky130_fd_pr__nfet_01v8 ad=0.08775 pd=0.92 as=0.169 ps=1.82 w=0.65 l=0.15
X364 sky130_fd_sc_hd__inv_1_140.A sky130_fd_sc_hd__inv_1_141.A vdd sky130_fd_sc_hd__nand2_1_52.VPB sky130_fd_pr__pfet_01v8_hvt ad=0.26 pd=2.52 as=0.26 ps=2.52 w=1 l=0.15
X365 sky130_fd_sc_hd__nand2_1_2.B sample vss sky130_fd_sc_hd__nand2_1_59.VNB sky130_fd_pr__nfet_01v8 ad=0.08775 pd=0.92 as=0.169 ps=1.82 w=0.65 l=0.15
X366 sky130_fd_sc_hd__inv_1_124.A sky130_fd_sc_hd__inv_1_125.A vss sky130_fd_sc_hd__nand2_1_59.VNB sky130_fd_pr__nfet_01v8 ad=0.169 pd=1.82 as=0.169 ps=1.82 w=0.65 l=0.15
X367 sky130_fd_sc_hd__inv_1_68.A sky130_fd_sc_hd__nand2_1_2.B vdd sky130_fd_sc_hd__nand2_1_28.VPB sky130_fd_pr__pfet_01v8_hvt ad=0.26 pd=2.52 as=0.26 ps=2.52 w=1 l=0.15
X368 sky130_fd_sc_hd__nand2_1_48.B sky130_fd_sc_hd__inv_1_115.A vdd sky130_fd_sc_hd__nand2_1_44.VPB sky130_fd_pr__pfet_01v8_hvt ad=0.26 pd=2.52 as=0.26 ps=2.52 w=1 l=0.15
X369 sky130_fd_sc_hd__nand2_1_43.B sky130_fd_sc_hd__inv_1_92.A vdd sky130_fd_sc_hd__nand2_1_36.VPB sky130_fd_pr__pfet_01v8_hvt ad=0.26 pd=2.52 as=0.26 ps=2.52 w=1 l=0.15
X370 a_3981_3855# sample sky130_fd_sc_hd__nand2_1_2.B sky130_fd_sc_hd__nand2_1_28.VPB sky130_fd_pr__pfet_01v8_hvt ad=0.105 pd=1.21 as=0.26 ps=2.52 w=1 l=0.15
X371 vdd sky130_fd_sc_hd__nand2_1_2.B a_753_7913# sky130_fd_sc_hd__nand2_1_3.VPB sky130_fd_pr__pfet_01v8_hvt ad=0.26 pd=2.52 as=0.105 ps=1.21 w=1 l=0.15
X372 sky130_fd_sc_hd__inv_1_98.A sky130_fd_sc_hd__nand2_1_2.B vss sky130_fd_sc_hd__nand2_1_59.VNB sky130_fd_pr__nfet_01v8 ad=0.169 pd=1.82 as=0.169 ps=1.82 w=0.65 l=0.15
X373 sky130_fd_sc_hd__nand2_1_51.B sky130_fd_sc_hd__inv_1_122.A vss sky130_fd_sc_hd__nand2_1_59.VNB sky130_fd_pr__nfet_01v8 ad=0.169 pd=1.82 as=0.169 ps=1.82 w=0.65 l=0.15
X374 sky130_fd_sc_hd__inv_1_146.A sky130_fd_sc_hd__inv_1_147.A vdd sky130_fd_sc_hd__nand2_1_52.VPB sky130_fd_pr__pfet_01v8_hvt ad=0.26 pd=2.52 as=0.26 ps=2.52 w=1 l=0.15
X375 sky130_fd_sc_hd__inv_1_49.A sky130_fd_sc_hd__inv_1_50.A vdd sky130_fd_sc_hd__nand2_1_28.VPB sky130_fd_pr__pfet_01v8_hvt ad=0.26 pd=2.52 as=0.26 ps=2.52 w=1 l=0.15
X376 sky130_fd_sc_hd__nand2_1_2.A sky130_fd_sc_hd__inv_1_154.A vdd sky130_fd_sc_hd__nand2_1_52.VPB sky130_fd_pr__pfet_01v8_hvt ad=0.26 pd=2.52 as=0.26 ps=2.52 w=1 l=0.15
X377 sky130_fd_sc_hd__nand2_1_7.B sky130_fd_sc_hd__nand2_1_2.B vdd sky130_fd_sc_hd__nand2_1_3.VPB sky130_fd_pr__pfet_01v8_hvt ad=0.26 pd=2.52 as=0.26 ps=2.52 w=1 l=0.15
X378 sky130_fd_sc_hd__nand2_1_36.B sky130_fd_sc_hd__inv_1_70.A vdd sky130_fd_sc_hd__nand2_1_36.VPB sky130_fd_pr__pfet_01v8_hvt ad=0.26 pd=2.52 as=0.26 ps=2.52 w=1 l=0.15
X379 sky130_fd_sc_hd__nand2_1_31.B sky130_fd_sc_hd__inv_1_47.A vdd sky130_fd_sc_hd__nand2_1_28.VPB sky130_fd_pr__pfet_01v8_hvt ad=0.26 pd=2.52 as=0.26 ps=2.52 w=1 l=0.15
X380 vdd sky130_fd_sc_hd__nand2_1_2.A sky130_fd_sc_hd__inv_1_130.A sky130_fd_sc_hd__nand2_1_52.VPB sky130_fd_pr__pfet_01v8_hvt ad=0.26 pd=2.52 as=0.135 ps=1.27 w=1 l=0.15
X381 sky130_fd_sc_hd__nand2_1_2.A sky130_fd_sc_hd__nand2_1_47.B vdd sky130_fd_sc_hd__nand2_1_44.VPB sky130_fd_pr__pfet_01v8_hvt ad=0.135 pd=1.27 as=0.26 ps=2.52 w=1 l=0.15
X382 vss sky130_fd_sc_hd__nand2_1_2.B sky130_fd_sc_hd__nand2_1_2.B sky130_fd_sc_hd__nand2_1_59.VNB sky130_fd_pr__nfet_01v8 ad=0.169 pd=1.82 as=0.08775 ps=0.92 w=0.65 l=0.15
X383 sky130_fd_sc_hd__nand2_1_2.B sky130_fd_sc_hd__nand2_1_2.B vss sky130_fd_sc_hd__nand2_1_59.VNB sky130_fd_pr__nfet_01v8 ad=0.08775 pd=0.92 as=0.169 ps=1.82 w=0.65 l=0.15
X384 sky130_fd_sc_hd__inv_1_73.A sky130_fd_sc_hd__inv_1_74.A vss sky130_fd_sc_hd__nand2_1_59.VNB sky130_fd_pr__nfet_01v8 ad=0.169 pd=1.82 as=0.169 ps=1.82 w=0.65 l=0.15
X385 sky130_fd_sc_hd__inv_1_9.A outn a_1309_7439# sky130_fd_sc_hd__nand2_1_59.VNB sky130_fd_pr__nfet_01v8 ad=0.169 pd=1.82 as=0.08775 ps=0.92 w=0.65 l=0.15
X386 sky130_fd_sc_hd__nand2_1_2.B sample vss sky130_fd_sc_hd__nand2_1_59.VNB sky130_fd_pr__nfet_01v8 ad=0.08775 pd=0.92 as=0.169 ps=1.82 w=0.65 l=0.15
X387 sky130_fd_sc_hd__inv_1_32.A sky130_fd_sc_hd__inv_1_33.A vdd sky130_fd_sc_hd__nand2_1_21.VPB sky130_fd_pr__pfet_01v8_hvt ad=0.26 pd=2.52 as=0.26 ps=2.52 w=1 l=0.15
X388 vss sky130_fd_sc_hd__nand2_1_2.B sky130_fd_sc_hd__nand2_1_2.B sky130_fd_sc_hd__nand2_1_59.VNB sky130_fd_pr__nfet_01v8 ad=0.169 pd=1.82 as=0.08775 ps=0.92 w=0.65 l=0.15
X389 bit3_b bit3 a_2137_7439# sky130_fd_sc_hd__nand2_1_59.VNB sky130_fd_pr__nfet_01v8 ad=0.169 pd=1.82 as=0.08775 ps=0.92 w=0.65 l=0.15
X390 a_753_5737# sample sky130_fd_sc_hd__nand2_1_2.B sky130_fd_sc_hd__nand2_1_15.VPB sky130_fd_pr__pfet_01v8_hvt ad=0.105 pd=1.21 as=0.26 ps=2.52 w=1 l=0.15
X391 vss sky130_fd_sc_hd__nand2_1_2.B sky130_fd_sc_hd__nand2_1_2.B sky130_fd_sc_hd__nand2_1_59.VNB sky130_fd_pr__nfet_01v8 ad=0.169 pd=1.82 as=0.08775 ps=0.92 w=0.65 l=0.15
X392 sky130_fd_sc_hd__nand2_1_12.B sky130_fd_sc_hd__inv_1_12.A vss sky130_fd_sc_hd__nand2_1_59.VNB sky130_fd_pr__nfet_01v8 ad=0.169 pd=1.82 as=0.169 ps=1.82 w=0.65 l=0.15
X393 sky130_fd_sc_hd__inv_1_15.A sky130_fd_sc_hd__nand2_1_2.B a_1309_6351# sky130_fd_sc_hd__nand2_1_59.VNB sky130_fd_pr__nfet_01v8 ad=0.169 pd=1.82 as=0.08775 ps=0.92 w=0.65 l=0.15
X394 sky130_fd_sc_hd__inv_1_109.A sky130_fd_sc_hd__inv_1_110.A vss sky130_fd_sc_hd__nand2_1_59.VNB sky130_fd_pr__nfet_01v8 ad=0.169 pd=1.82 as=0.169 ps=1.82 w=0.65 l=0.15
X395 a_109_7439# sky130_fd_sc_hd__nand2_1_2.B vss sky130_fd_sc_hd__nand2_1_59.VNB sky130_fd_pr__nfet_01v8 ad=0.08775 pd=0.92 as=0.169 ps=1.82 w=0.65 l=0.15
X396 vss sky130_fd_sc_hd__nand2_1_2.B sky130_fd_sc_hd__nand2_1_2.B sky130_fd_sc_hd__nand2_1_59.VNB sky130_fd_pr__nfet_01v8 ad=0.169 pd=1.82 as=0.08775 ps=0.92 w=0.65 l=0.15
X397 sky130_fd_sc_hd__inv_1_135.A sky130_fd_sc_hd__nand2_1_2.A vdd sky130_fd_sc_hd__nand2_1_52.VPB sky130_fd_pr__pfet_01v8_hvt ad=0.26 pd=2.52 as=0.26 ps=2.52 w=1 l=0.15
X398 sky130_fd_sc_hd__inv_1_134.A sky130_fd_sc_hd__inv_1_135.A vss sky130_fd_sc_hd__nand2_1_59.VNB sky130_fd_pr__nfet_01v8 ad=0.169 pd=1.82 as=0.169 ps=1.82 w=0.65 l=0.15
X399 sky130_fd_sc_hd__inv_1_70.A sky130_fd_sc_hd__nand2_1_2.A a_4537_3087# sky130_fd_sc_hd__nand2_1_59.VNB sky130_fd_pr__nfet_01v8 ad=0.169 pd=1.82 as=0.08775 ps=0.92 w=0.65 l=0.15
X400 sky130_fd_sc_hd__nand2_1_2.B sample vdd sky130_fd_sc_hd__nand2_1_3.VPB sky130_fd_pr__pfet_01v8_hvt ad=0.26 pd=2.52 as=0.26 ps=2.52 w=1 l=0.15
X401 sky130_fd_sc_hd__inv_1_12.A sky130_fd_sc_hd__nand2_1_2.B vdd sky130_fd_sc_hd__nand2_1_9.VPB sky130_fd_pr__pfet_01v8_hvt ad=0.135 pd=1.27 as=0.26 ps=2.52 w=1 l=0.15
X402 sky130_fd_sc_hd__inv_1_141.A sky130_fd_sc_hd__inv_1_142.A vdd sky130_fd_sc_hd__nand2_1_52.VPB sky130_fd_pr__pfet_01v8_hvt ad=0.26 pd=2.52 as=0.26 ps=2.52 w=1 l=0.15
X403 sky130_fd_sc_hd__inv_1_62.A sky130_fd_sc_hd__inv_1_63.A vdd sky130_fd_sc_hd__nand2_1_28.VPB sky130_fd_pr__pfet_01v8_hvt ad=0.26 pd=2.52 as=0.26 ps=2.52 w=1 l=0.15
X404 sky130_fd_sc_hd__nand2_1_2.B sample vss sky130_fd_sc_hd__nand2_1_59.VNB sky130_fd_pr__nfet_01v8 ad=0.169 pd=1.82 as=0.169 ps=1.82 w=0.65 l=0.15
X405 sky130_fd_sc_hd__inv_1_112.A sky130_fd_sc_hd__inv_1_113.A vdd sky130_fd_sc_hd__nand2_1_44.VPB sky130_fd_pr__pfet_01v8_hvt ad=0.26 pd=2.52 as=0.26 ps=2.52 w=1 l=0.15
X406 sky130_fd_sc_hd__nand2_1_47.B sky130_fd_sc_hd__inv_1_107.A vss sky130_fd_sc_hd__nand2_1_59.VNB sky130_fd_pr__nfet_01v8 ad=0.169 pd=1.82 as=0.169 ps=1.82 w=0.65 l=0.15
X407 bit5_b bit5 a_2137_6351# sky130_fd_sc_hd__nand2_1_59.VNB sky130_fd_pr__nfet_01v8 ad=0.169 pd=1.82 as=0.08775 ps=0.92 w=0.65 l=0.15
X408 a_2137_5487# sky130_fd_sc_hd__nand2_1_18.B vss sky130_fd_sc_hd__nand2_1_59.VNB sky130_fd_pr__nfet_01v8 ad=0.08775 pd=0.92 as=0.169 ps=1.82 w=0.65 l=0.15
X409 vdd outn sky130_fd_sc_hd__nand2_1_2.A sky130_fd_sc_hd__nand2_1_21.VPB sky130_fd_pr__pfet_01v8_hvt ad=0.165 pd=1.33 as=0.135 ps=1.27 w=1 l=0.15
X410 sky130_fd_sc_hd__inv_1_92.A sky130_fd_sc_hd__inv_1_93.A vss sky130_fd_sc_hd__nand2_1_59.VNB sky130_fd_pr__nfet_01v8 ad=0.169 pd=1.82 as=0.169 ps=1.82 w=0.65 l=0.15
X411 sky130_fd_sc_hd__inv_1_74.A sky130_fd_sc_hd__inv_1_75.A vss sky130_fd_sc_hd__nand2_1_59.VNB sky130_fd_pr__nfet_01v8 ad=0.169 pd=1.82 as=0.169 ps=1.82 w=0.65 l=0.15
X412 vss sky130_fd_sc_hd__nand2_1_2.B sky130_fd_sc_hd__nand2_1_2.B sky130_fd_sc_hd__nand2_1_59.VNB sky130_fd_pr__nfet_01v8 ad=0.169 pd=1.82 as=0.08775 ps=0.92 w=0.65 l=0.15
X413 a_109_6351# sky130_fd_sc_hd__nand2_1_2.B vss sky130_fd_sc_hd__nand2_1_59.VNB sky130_fd_pr__nfet_01v8 ad=0.08775 pd=0.92 as=0.169 ps=1.82 w=0.65 l=0.15
X414 sky130_fd_sc_hd__inv_1_66.A sky130_fd_sc_hd__inv_1_67.A vss sky130_fd_sc_hd__nand2_1_59.VNB sky130_fd_pr__nfet_01v8 ad=0.169 pd=1.82 as=0.169 ps=1.82 w=0.65 l=0.15
X415 sky130_fd_sc_hd__nand2_1_33.B sky130_fd_sc_hd__nand2_1_2.B vss sky130_fd_sc_hd__nand2_1_59.VNB sky130_fd_pr__nfet_01v8 ad=0.169 pd=1.82 as=0.169 ps=1.82 w=0.65 l=0.15
X416 sky130_fd_sc_hd__nand2_1_2.B sample vss sky130_fd_sc_hd__nand2_1_59.VNB sky130_fd_pr__nfet_01v8 ad=0.169 pd=1.82 as=0.169 ps=1.82 w=0.65 l=0.15
X417 a_1861_5487# sky130_fd_sc_hd__nand2_1_19.B vss sky130_fd_sc_hd__nand2_1_59.VNB sky130_fd_pr__nfet_01v8 ad=0.08775 pd=0.92 as=0.169 ps=1.82 w=0.65 l=0.15
X418 a_5089_911# sky130_fd_sc_hd__nand2_1_2.B vss sky130_fd_sc_hd__nand2_1_59.VNB sky130_fd_pr__nfet_01v8 ad=0.08775 pd=0.92 as=0.169 ps=1.82 w=0.65 l=0.15
X419 bit2_b sky130_fd_sc_hd__nand2_1_6.B vdd sky130_fd_sc_hd__nand2_1_3.VPB sky130_fd_pr__pfet_01v8_hvt ad=0.135 pd=1.27 as=0.26 ps=2.52 w=1 l=0.15
X420 sky130_fd_sc_hd__inv_1_24.A sky130_fd_sc_hd__nand2_1_2.A a_4813_4399# sky130_fd_sc_hd__nand2_1_59.VNB sky130_fd_pr__nfet_01v8 ad=0.169 pd=1.82 as=0.08775 ps=0.92 w=0.65 l=0.15
X421 a_3981_591# sample sky130_fd_sc_hd__nand2_1_2.B sky130_fd_sc_hd__nand2_1_52.VPB sky130_fd_pr__pfet_01v8_hvt ad=0.105 pd=1.21 as=0.26 ps=2.52 w=1 l=0.15
X422 sky130_fd_sc_hd__inv_1_155.A outn vdd sky130_fd_sc_hd__nand2_1_52.VPB sky130_fd_pr__pfet_01v8_hvt ad=0.135 pd=1.27 as=0.26 ps=2.52 w=1 l=0.15
X423 sky130_fd_sc_hd__nand2_1_2.B sample vdd sky130_fd_sc_hd__nand2_1_44.VPB sky130_fd_pr__pfet_01v8_hvt ad=0.26 pd=2.52 as=0.26 ps=2.52 w=1 l=0.15
X424 sky130_fd_sc_hd__nand2_1_2.B sample vss sky130_fd_sc_hd__nand2_1_59.VNB sky130_fd_pr__nfet_01v8 ad=0.169 pd=1.82 as=0.169 ps=1.82 w=0.65 l=0.15
X425 sky130_fd_sc_hd__nand2_1_2.B sky130_fd_sc_hd__nand2_1_25.B vdd sky130_fd_sc_hd__nand2_1_21.VPB sky130_fd_pr__pfet_01v8_hvt ad=0.135 pd=1.27 as=0.26 ps=2.52 w=1 l=0.15
X426 sky130_fd_sc_hd__nand2_1_52.B sky130_fd_sc_hd__inv_1_130.A vss sky130_fd_sc_hd__nand2_1_59.VNB sky130_fd_pr__nfet_01v8 ad=0.169 pd=1.82 as=0.169 ps=1.82 w=0.65 l=0.15
X427 sky130_fd_sc_hd__inv_1_103.A sky130_fd_sc_hd__inv_1_104.A vdd sky130_fd_sc_hd__nand2_1_44.VPB sky130_fd_pr__pfet_01v8_hvt ad=0.26 pd=2.52 as=0.26 ps=2.52 w=1 l=0.15
X428 sky130_fd_sc_hd__inv_1_60.A sky130_fd_sc_hd__nand2_1_2.A vss sky130_fd_sc_hd__nand2_1_59.VNB sky130_fd_pr__nfet_01v8 ad=0.169 pd=1.82 as=0.169 ps=1.82 w=0.65 l=0.15
X429 sky130_fd_sc_hd__nand2_1_2.B sky130_fd_sc_hd__nand2_1_32.Y a_5089_3311# sky130_fd_sc_hd__nand2_1_59.VNB sky130_fd_pr__nfet_01v8 ad=0.169 pd=1.82 as=0.08775 ps=0.92 w=0.65 l=0.15
X430 sky130_fd_sc_hd__inv_1_148.A sky130_fd_sc_hd__inv_1_149.A vss sky130_fd_sc_hd__nand2_1_59.VNB sky130_fd_pr__nfet_01v8 ad=0.169 pd=1.82 as=0.169 ps=1.82 w=0.65 l=0.15
X431 sky130_fd_sc_hd__inv_1_83.A sky130_fd_sc_hd__nand2_1_2.B vss sky130_fd_sc_hd__nand2_1_59.VNB sky130_fd_pr__nfet_01v8 ad=0.169 pd=1.82 as=0.169 ps=1.82 w=0.65 l=0.15
X432 sky130_fd_sc_hd__inv_1_55.A sky130_fd_sc_hd__nand2_1_2.B vdd sky130_fd_sc_hd__nand2_1_28.VPB sky130_fd_pr__pfet_01v8_hvt ad=0.135 pd=1.27 as=0.26 ps=2.52 w=1 l=0.15
X433 sky130_fd_sc_hd__nand2_1_24.Y sky130_fd_sc_hd__nand2_1_2.B a_5641_4399# sky130_fd_sc_hd__nand2_1_59.VNB sky130_fd_pr__nfet_01v8 ad=0.169 pd=1.82 as=0.08775 ps=0.92 w=0.65 l=0.15
X434 sky130_fd_sc_hd__nand2_1_2.A sky130_fd_sc_hd__nand2_1_2.A vdd sky130_fd_sc_hd__nand2_1_9.VPB sky130_fd_pr__pfet_01v8_hvt ad=0.26 pd=2.52 as=0.165 ps=1.33 w=1 l=0.15
X435 a_4537_2223# sky130_fd_sc_hd__nand2_1_2.B vss sky130_fd_sc_hd__nand2_1_59.VNB sky130_fd_pr__nfet_01v8 ad=0.08775 pd=0.92 as=0.169 ps=1.82 w=0.65 l=0.15
X436 sky130_fd_sc_hd__nand2_1_2.B sky130_fd_sc_hd__inv_1_58.A vss sky130_fd_sc_hd__nand2_1_59.VNB sky130_fd_pr__nfet_01v8 ad=0.169 pd=1.82 as=0.169 ps=1.82 w=0.65 l=0.15
X437 vdd sky130_fd_sc_hd__nand2_1_2.A sky130_fd_sc_hd__inv_1_21.A sky130_fd_sc_hd__nand2_1_21.VPB sky130_fd_pr__pfet_01v8_hvt ad=0.26 pd=2.52 as=0.135 ps=1.27 w=1 l=0.15
X438 sky130_fd_sc_hd__inv_1_147.A sky130_fd_sc_hd__inv_1_148.A vdd sky130_fd_sc_hd__nand2_1_52.VPB sky130_fd_pr__pfet_01v8_hvt ad=0.26 pd=2.52 as=0.26 ps=2.52 w=1 l=0.15
X439 sky130_fd_sc_hd__nand2_1_32.Y sky130_fd_sc_hd__nand2_1_32.B vdd sky130_fd_sc_hd__nand2_1_28.VPB sky130_fd_pr__pfet_01v8_hvt ad=0.135 pd=1.27 as=0.26 ps=2.52 w=1 l=0.15
X440 a_753_7119# sample sky130_fd_sc_hd__nand2_1_2.B sky130_fd_sc_hd__nand2_1_9.VPB sky130_fd_pr__pfet_01v8_hvt ad=0.105 pd=1.21 as=0.26 ps=2.52 w=1 l=0.15
X441 sky130_fd_sc_hd__inv_1_154.A sky130_fd_sc_hd__inv_1_155.A vdd sky130_fd_sc_hd__nand2_1_52.VPB sky130_fd_pr__pfet_01v8_hvt ad=0.26 pd=2.52 as=0.26 ps=2.52 w=1 l=0.15
X442 a_193_6575# outn a_109_6575# sky130_fd_sc_hd__nand2_1_59.VNB sky130_fd_pr__nfet_01v8 ad=0.10725 pd=0.98 as=0.08775 ps=0.92 w=0.65 l=0.15
X443 vdd sky130_fd_sc_hd__nand2_1_2.A sky130_fd_sc_hd__inv_1_100.A sky130_fd_sc_hd__nand2_1_44.VPB sky130_fd_pr__pfet_01v8_hvt ad=0.26 pd=2.52 as=0.135 ps=1.27 w=1 l=0.15
X444 a_5365_2223# sky130_fd_sc_hd__nand2_1_40.B vss sky130_fd_sc_hd__nand2_1_59.VNB sky130_fd_pr__nfet_01v8 ad=0.08775 pd=0.92 as=0.169 ps=1.82 w=0.65 l=0.15
X445 bit2 sky130_fd_sc_hd__nand2_1_7.B vdd sky130_fd_sc_hd__nand2_1_3.VPB sky130_fd_pr__pfet_01v8_hvt ad=0.135 pd=1.27 as=0.26 ps=2.52 w=1 l=0.15
X446 sky130_fd_sc_hd__nand2_1_2.B sample vdd sky130_fd_sc_hd__nand2_1_36.VPB sky130_fd_pr__pfet_01v8_hvt ad=0.26 pd=2.52 as=0.26 ps=2.52 w=1 l=0.15
X447 vdd bit7 bit7_b sky130_fd_sc_hd__nand2_1_21.VPB sky130_fd_pr__pfet_01v8_hvt ad=0.26 pd=2.52 as=0.135 ps=1.27 w=1 l=0.15
X448 sky130_fd_sc_hd__inv_1_3.A sky130_fd_sc_hd__nand2_1_2.B vdd sky130_fd_sc_hd__nand2_1_3.VPB sky130_fd_pr__pfet_01v8_hvt ad=0.135 pd=1.27 as=0.26 ps=2.52 w=1 l=0.15
X449 sky130_fd_sc_hd__inv_1_95.A sky130_fd_sc_hd__inv_1_96.A vdd sky130_fd_sc_hd__nand2_1_36.VPB sky130_fd_pr__pfet_01v8_hvt ad=0.26 pd=2.52 as=0.26 ps=2.52 w=1 l=0.15
X450 sky130_fd_sc_hd__nand2_1_10.B sky130_fd_sc_hd__nand2_1_2.B vss sky130_fd_sc_hd__nand2_1_59.VNB sky130_fd_pr__nfet_01v8 ad=0.169 pd=1.82 as=0.169 ps=1.82 w=0.65 l=0.15
X451 sky130_fd_sc_hd__inv_1_104.A sky130_fd_sc_hd__inv_1_105.A vdd sky130_fd_sc_hd__nand2_1_44.VPB sky130_fd_pr__pfet_01v8_hvt ad=0.26 pd=2.52 as=0.26 ps=2.52 w=1 l=0.15
X452 a_753_6031# sample sky130_fd_sc_hd__nand2_1_2.B sky130_fd_sc_hd__nand2_1_15.VPB sky130_fd_pr__pfet_01v8_hvt ad=0.105 pd=1.21 as=0.26 ps=2.52 w=1 l=0.15
X453 sky130_fd_sc_hd__nand2_1_2.A sky130_fd_sc_hd__nand2_1_2.B vdd sky130_fd_sc_hd__nand2_1_21.VPB sky130_fd_pr__pfet_01v8_hvt ad=0.135 pd=1.27 as=0.26 ps=2.52 w=1 l=0.15
X454 vss sky130_fd_sc_hd__nand2_1_2.B sky130_fd_sc_hd__nand2_1_2.B sky130_fd_sc_hd__nand2_1_59.VNB sky130_fd_pr__nfet_01v8 ad=0.169 pd=1.82 as=0.08775 ps=0.92 w=0.65 l=0.15
X455 sky130_fd_sc_hd__nand2_1_0.B sky130_fd_sc_hd__inv_1_0.A vdd sky130_fd_sc_hd__nand2_1_0.VPB sky130_fd_pr__pfet_01v8_hvt ad=0.26 pd=2.52 as=0.26 ps=2.52 w=1 l=0.15
X456 sky130_fd_sc_hd__inv_1_125.A sky130_fd_sc_hd__inv_1_126.A vss sky130_fd_sc_hd__nand2_1_59.VNB sky130_fd_pr__nfet_01v8 ad=0.169 pd=1.82 as=0.169 ps=1.82 w=0.65 l=0.15
X457 sky130_fd_sc_hd__nand2_1_2.B sample vss sky130_fd_sc_hd__nand2_1_59.VNB sky130_fd_pr__nfet_01v8 ad=0.08775 pd=0.92 as=0.169 ps=1.82 w=0.65 l=0.15
X458 sky130_fd_sc_hd__nand2_1_16.B sky130_fd_sc_hd__nand2_1_2.B vss sky130_fd_sc_hd__nand2_1_59.VNB sky130_fd_pr__nfet_01v8 ad=0.169 pd=1.82 as=0.169 ps=1.82 w=0.65 l=0.15
X459 a_2321_3311# sky130_fd_sc_hd__nand2_1_35.B vss sky130_fd_sc_hd__nand2_1_59.VNB sky130_fd_pr__nfet_01v8 ad=0.08775 pd=0.92 as=0.169 ps=1.82 w=0.65 l=0.15
X460 sky130_fd_sc_hd__inv_1_50.A sky130_fd_sc_hd__inv_1_51.A vdd sky130_fd_sc_hd__nand2_1_28.VPB sky130_fd_pr__pfet_01v8_hvt ad=0.26 pd=2.52 as=0.26 ps=2.52 w=1 l=0.15
X461 a_1309_8751# sky130_fd_sc_hd__nand2_1_2.B vss sky130_fd_sc_hd__nand2_1_59.VNB sky130_fd_pr__nfet_01v8 ad=0.08775 pd=0.92 as=0.169 ps=1.82 w=0.65 l=0.15
X462 sky130_fd_sc_hd__inv_1_142.A sky130_fd_sc_hd__inv_1_143.A vdd sky130_fd_sc_hd__nand2_1_52.VPB sky130_fd_pr__pfet_01v8_hvt ad=0.26 pd=2.52 as=0.26 ps=2.52 w=1 l=0.15
X463 sky130_fd_sc_hd__inv_1_33.A sky130_fd_sc_hd__inv_1_34.A vdd sky130_fd_sc_hd__nand2_1_21.VPB sky130_fd_pr__pfet_01v8_hvt ad=0.26 pd=2.52 as=0.26 ps=2.52 w=1 l=0.15
X464 sky130_fd_sc_hd__inv_1_77.A sky130_fd_sc_hd__inv_1_78.A vss sky130_fd_sc_hd__nand2_1_59.VNB sky130_fd_pr__nfet_01v8 ad=0.169 pd=1.82 as=0.169 ps=1.82 w=0.65 l=0.15
X465 vdd sky130_fd_sc_hd__nand2_1_2.B sky130_fd_sc_hd__nand2_1_40.Y sky130_fd_sc_hd__nand2_1_36.VPB sky130_fd_pr__pfet_01v8_hvt ad=0.26 pd=2.52 as=0.135 ps=1.27 w=1 l=0.15
X466 sky130_fd_sc_hd__inv_1_51.A sky130_fd_sc_hd__inv_1_52.A vss sky130_fd_sc_hd__nand2_1_59.VNB sky130_fd_pr__nfet_01v8 ad=0.169 pd=1.82 as=0.169 ps=1.82 w=0.65 l=0.15
X467 sky130_fd_sc_hd__nand2_1_48.Y sky130_fd_sc_hd__nand2_1_2.B a_5365_1135# sky130_fd_sc_hd__nand2_1_59.VNB sky130_fd_pr__nfet_01v8 ad=0.169 pd=1.82 as=0.08775 ps=0.92 w=0.65 l=0.15
X468 sky130_fd_sc_hd__inv_1_63.A sky130_fd_sc_hd__inv_1_64.A vdd sky130_fd_sc_hd__nand2_1_28.VPB sky130_fd_pr__pfet_01v8_hvt ad=0.26 pd=2.52 as=0.26 ps=2.52 w=1 l=0.15
X469 vdd bit4_b bit4 sky130_fd_sc_hd__nand2_1_9.VPB sky130_fd_pr__pfet_01v8_hvt ad=0.26 pd=2.52 as=0.135 ps=1.27 w=1 l=0.15
X470 sky130_fd_sc_hd__nand2_1_29.B sky130_fd_sc_hd__nand2_1_2.B vss sky130_fd_sc_hd__nand2_1_59.VNB sky130_fd_pr__nfet_01v8 ad=0.169 pd=1.82 as=0.169 ps=1.82 w=0.65 l=0.15
X471 sky130_fd_sc_hd__inv_1_113.A sky130_fd_sc_hd__nand2_1_2.B vdd sky130_fd_sc_hd__nand2_1_44.VPB sky130_fd_pr__pfet_01v8_hvt ad=0.26 pd=2.52 as=0.26 ps=2.52 w=1 l=0.15
X472 a_1309_5263# sky130_fd_sc_hd__nand2_1_2.B vss sky130_fd_sc_hd__nand2_1_59.VNB sky130_fd_pr__nfet_01v8 ad=0.08775 pd=0.92 as=0.169 ps=1.82 w=0.65 l=0.15
X473 sky130_fd_sc_hd__inv_1_67.A sky130_fd_sc_hd__inv_1_68.A vss sky130_fd_sc_hd__nand2_1_59.VNB sky130_fd_pr__nfet_01v8 ad=0.169 pd=1.82 as=0.169 ps=1.82 w=0.65 l=0.15
X474 sky130_fd_sc_hd__inv_1_12.A sky130_fd_sc_hd__nand2_1_2.A a_1309_6575# sky130_fd_sc_hd__nand2_1_59.VNB sky130_fd_pr__nfet_01v8 ad=0.169 pd=1.82 as=0.08775 ps=0.92 w=0.65 l=0.15
X475 sky130_fd_sc_hd__inv_1_148.A sky130_fd_sc_hd__inv_1_149.A vdd sky130_fd_sc_hd__nand2_1_52.VPB sky130_fd_pr__pfet_01v8_hvt ad=0.26 pd=2.52 as=0.26 ps=2.52 w=1 l=0.15
X476 sky130_fd_sc_hd__inv_1_93.A sky130_fd_sc_hd__inv_1_94.A vss sky130_fd_sc_hd__nand2_1_59.VNB sky130_fd_pr__nfet_01v8 ad=0.169 pd=1.82 as=0.169 ps=1.82 w=0.65 l=0.15
X477 vdd sky130_fd_sc_hd__nand2_1_2.A sky130_fd_sc_hd__nand2_1_2.A sky130_fd_sc_hd__nand2_1_21.VPB sky130_fd_pr__pfet_01v8_hvt ad=0.26 pd=2.52 as=0.135 ps=1.27 w=1 l=0.15
X478 vdd sky130_fd_sc_hd__nand2_1_2.B a_3981_1385# sky130_fd_sc_hd__nand2_1_44.VPB sky130_fd_pr__pfet_01v8_hvt ad=0.26 pd=2.52 as=0.105 ps=1.21 w=1 l=0.15
X479 sky130_fd_sc_hd__inv_1_110.A sky130_fd_sc_hd__inv_1_111.A vss sky130_fd_sc_hd__nand2_1_59.VNB sky130_fd_pr__nfet_01v8 ad=0.169 pd=1.82 as=0.169 ps=1.82 w=0.65 l=0.15
X480 outn sky130_fd_sc_hd__nand2_1_2.A vdd sky130_fd_sc_hd__nand2_1_3.VPB sky130_fd_pr__pfet_01v8_hvt ad=0.26 pd=2.52 as=0.165 ps=1.33 w=1 l=0.15
X481 bit4_b bit4 a_2137_6575# sky130_fd_sc_hd__nand2_1_59.VNB sky130_fd_pr__nfet_01v8 ad=0.169 pd=1.82 as=0.08775 ps=0.92 w=0.65 l=0.15
X482 vdd sky130_fd_sc_hd__nand2_1_2.B sky130_fd_sc_hd__nand2_1_28.Y sky130_fd_sc_hd__nand2_1_28.VPB sky130_fd_pr__pfet_01v8_hvt ad=0.26 pd=2.52 as=0.135 ps=1.27 w=1 l=0.15
X483 sky130_fd_sc_hd__nand2_1_3.B sky130_fd_sc_hd__inv_1_3.A vss sky130_fd_sc_hd__nand2_1_59.VNB sky130_fd_pr__nfet_01v8 ad=0.169 pd=1.82 as=0.169 ps=1.82 w=0.65 l=0.15
X484 vss sky130_fd_sc_hd__nand2_1_2.B sky130_fd_sc_hd__nand2_1_2.B sky130_fd_sc_hd__nand2_1_59.VNB sky130_fd_pr__nfet_01v8 ad=0.169 pd=1.82 as=0.08775 ps=0.92 w=0.65 l=0.15
X485 a_109_6575# sky130_fd_sc_hd__nand2_1_2.B vss sky130_fd_sc_hd__nand2_1_59.VNB sky130_fd_pr__nfet_01v8 ad=0.08775 pd=0.92 as=0.169 ps=1.82 w=0.65 l=0.15
X486 vdd sky130_fd_sc_hd__nand2_1_2.B a_753_4943# sky130_fd_sc_hd__nand2_1_21.VPB sky130_fd_pr__pfet_01v8_hvt ad=0.26 pd=2.52 as=0.105 ps=1.21 w=1 l=0.15
X487 vdd sky130_fd_sc_hd__nand2_1_2.A sky130_fd_sc_hd__nand2_1_2.A sky130_fd_sc_hd__nand2_1_28.VPB sky130_fd_pr__pfet_01v8_hvt ad=0.26 pd=2.52 as=0.135 ps=1.27 w=1 l=0.15
X488 sky130_fd_sc_hd__nand2_1_25.B sky130_fd_sc_hd__inv_1_25.A vss sky130_fd_sc_hd__nand2_1_59.VNB sky130_fd_pr__nfet_01v8 ad=0.169 pd=1.82 as=0.169 ps=1.82 w=0.65 l=0.15
X489 sky130_fd_sc_hd__nand2_1_2.A sky130_fd_sc_hd__nand2_1_2.A a_2321_2223# sky130_fd_sc_hd__nand2_1_59.VNB sky130_fd_pr__nfet_01v8 ad=0.169 pd=1.82 as=0.08775 ps=0.92 w=0.65 l=0.15
X490 a_2137_7439# sky130_fd_sc_hd__nand2_1_9.B vss sky130_fd_sc_hd__nand2_1_59.VNB sky130_fd_pr__nfet_01v8 ad=0.08775 pd=0.92 as=0.169 ps=1.82 w=0.65 l=0.15
X491 sky130_fd_sc_hd__inv_1_45.A sky130_fd_sc_hd__nand2_1_2.A vss sky130_fd_sc_hd__nand2_1_59.VNB sky130_fd_pr__nfet_01v8 ad=0.169 pd=1.82 as=0.169 ps=1.82 w=0.65 l=0.15
X492 sky130_fd_sc_hd__nand2_1_2.B sky130_fd_sc_hd__nand2_1_28.Y a_5089_4175# sky130_fd_sc_hd__nand2_1_59.VNB sky130_fd_pr__nfet_01v8 ad=0.169 pd=1.82 as=0.08775 ps=0.92 w=0.65 l=0.15
X493 vdd sky130_fd_sc_hd__nand2_1_2.B a_3981_2767# sky130_fd_sc_hd__nand2_1_36.VPB sky130_fd_pr__pfet_01v8_hvt ad=0.26 pd=2.52 as=0.105 ps=1.21 w=1 l=0.15
X494 vdd outn sky130_fd_sc_hd__nand2_1_2.A sky130_fd_sc_hd__nand2_1_0.VPB sky130_fd_pr__pfet_01v8_hvt ad=0.165 pd=1.33 as=0.135 ps=1.27 w=1 l=0.15
X495 sky130_fd_sc_hd__nand2_1_2.A sky130_fd_sc_hd__nand2_1_2.A a_193_8751# sky130_fd_sc_hd__nand2_1_59.VNB sky130_fd_pr__nfet_01v8 ad=0.169 pd=1.82 as=0.10725 ps=0.98 w=0.65 l=0.15
X496 sky130_fd_sc_hd__nand2_1_2.B sky130_fd_sc_hd__inv_1_43.A vss sky130_fd_sc_hd__nand2_1_59.VNB sky130_fd_pr__nfet_01v8 ad=0.169 pd=1.82 as=0.169 ps=1.82 w=0.65 l=0.15
X497 sky130_fd_sc_hd__nand2_1_22.B sky130_fd_sc_hd__nand2_1_2.B vdd sky130_fd_sc_hd__nand2_1_21.VPB sky130_fd_pr__pfet_01v8_hvt ad=0.26 pd=2.52 as=0.26 ps=2.52 w=1 l=0.15
X498 sky130_fd_sc_hd__nand2_1_2.B sky130_fd_sc_hd__nand2_1_2.B a_4805_47# sky130_fd_sc_hd__nand2_1_59.VNB sky130_fd_pr__nfet_01v8 ad=0.169 pd=1.82 as=0.08775 ps=0.92 w=0.65 l=0.15
X499 sky130_fd_sc_hd__inv_1_126.A sky130_fd_sc_hd__inv_1_127.A vdd sky130_fd_sc_hd__nand2_1_44.VPB sky130_fd_pr__pfet_01v8_hvt ad=0.26 pd=2.52 as=0.26 ps=2.52 w=1 l=0.15
X500 a_4537_3087# sky130_fd_sc_hd__nand2_1_2.B vss sky130_fd_sc_hd__nand2_1_59.VNB sky130_fd_pr__nfet_01v8 ad=0.08775 pd=0.92 as=0.169 ps=1.82 w=0.65 l=0.15
X501 sky130_fd_sc_hd__nand2_1_55.B sky130_fd_sc_hd__inv_1_137.A vdd sky130_fd_sc_hd__nand2_1_52.VPB sky130_fd_pr__pfet_01v8_hvt ad=0.26 pd=2.52 as=0.26 ps=2.52 w=1 l=0.15
X502 a_2137_6351# sky130_fd_sc_hd__nand2_1_15.B vss sky130_fd_sc_hd__nand2_1_59.VNB sky130_fd_pr__nfet_01v8 ad=0.08775 pd=0.92 as=0.169 ps=1.82 w=0.65 l=0.15
X503 sky130_fd_sc_hd__nand2_1_2.B sky130_fd_sc_hd__nand2_1_2.B vdd sky130_fd_sc_hd__nand2_1_44.VPB sky130_fd_pr__pfet_01v8_hvt ad=0.26 pd=2.52 as=0.26 ps=2.52 w=1 l=0.15
X504 sky130_fd_sc_hd__nand2_1_44.Y sky130_fd_sc_hd__nand2_1_2.B a_5365_1999# sky130_fd_sc_hd__nand2_1_59.VNB sky130_fd_pr__nfet_01v8 ad=0.169 pd=1.82 as=0.08775 ps=0.92 w=0.65 l=0.15
X505 sky130_fd_sc_hd__inv_1_58.A sky130_fd_sc_hd__inv_1_59.A vss sky130_fd_sc_hd__nand2_1_59.VNB sky130_fd_pr__nfet_01v8 ad=0.169 pd=1.82 as=0.169 ps=1.82 w=0.65 l=0.15
X506 a_5365_3087# sky130_fd_sc_hd__nand2_1_36.B vss sky130_fd_sc_hd__nand2_1_59.VNB sky130_fd_pr__nfet_01v8 ad=0.08775 pd=0.92 as=0.169 ps=1.82 w=0.65 l=0.15
X507 a_4257_4649# sample sky130_fd_sc_hd__inv_1_25.A sky130_fd_sc_hd__nand2_1_21.VPB sky130_fd_pr__pfet_01v8_hvt ad=0.105 pd=1.21 as=0.26 ps=2.52 w=1 l=0.15
X508 sky130_fd_sc_hd__nand2_1_2.B sky130_fd_sc_hd__nand2_1_33.B vdd sky130_fd_sc_hd__nand2_1_28.VPB sky130_fd_pr__pfet_01v8_hvt ad=0.135 pd=1.27 as=0.26 ps=2.52 w=1 l=0.15
X509 vss sky130_fd_sc_hd__nand2_1_2.B sky130_fd_sc_hd__nand2_1_2.B sky130_fd_sc_hd__nand2_1_59.VNB sky130_fd_pr__nfet_01v8 ad=0.169 pd=1.82 as=0.08775 ps=0.92 w=0.65 l=0.15
X510 sky130_fd_sc_hd__inv_1_107.A sky130_fd_sc_hd__inv_1_108.A vdd sky130_fd_sc_hd__nand2_1_44.VPB sky130_fd_pr__pfet_01v8_hvt ad=0.26 pd=2.52 as=0.26 ps=2.52 w=1 l=0.15
X511 a_1861_7439# sky130_fd_sc_hd__nand2_1_10.B vss sky130_fd_sc_hd__nand2_1_59.VNB sky130_fd_pr__nfet_01v8 ad=0.08775 pd=0.92 as=0.169 ps=1.82 w=0.65 l=0.15
X512 sky130_fd_sc_hd__nand2_1_2.B sample vss sky130_fd_sc_hd__nand2_1_59.VNB sky130_fd_pr__nfet_01v8 ad=0.169 pd=1.82 as=0.169 ps=1.82 w=0.65 l=0.15
X513 sky130_fd_sc_hd__nand2_1_2.A sky130_fd_sc_hd__nand2_1_2.A a_193_5263# sky130_fd_sc_hd__nand2_1_59.VNB sky130_fd_pr__nfet_01v8 ad=0.169 pd=1.82 as=0.10725 ps=0.98 w=0.65 l=0.15
X514 a_5089_2223# sky130_fd_sc_hd__nand2_1_41.B vss sky130_fd_sc_hd__nand2_1_59.VNB sky130_fd_pr__nfet_01v8 ad=0.08775 pd=0.92 as=0.169 ps=1.82 w=0.65 l=0.15
X515 sky130_fd_sc_hd__inv_1_81.A sky130_fd_sc_hd__inv_1_82.A vdd sky130_fd_sc_hd__nand2_1_36.VPB sky130_fd_pr__pfet_01v8_hvt ad=0.26 pd=2.52 as=0.26 ps=2.52 w=1 l=0.15
X516 sky130_fd_sc_hd__nand2_1_18.B sky130_fd_sc_hd__inv_1_18.A vdd sky130_fd_sc_hd__nand2_1_15.VPB sky130_fd_pr__pfet_01v8_hvt ad=0.26 pd=2.52 as=0.26 ps=2.52 w=1 l=0.15
X517 sky130_fd_sc_hd__inv_1_24.A sky130_fd_sc_hd__nand2_1_2.B vdd sky130_fd_sc_hd__nand2_1_21.VPB sky130_fd_pr__pfet_01v8_hvt ad=0.135 pd=1.27 as=0.26 ps=2.52 w=1 l=0.15
X518 sky130_fd_sc_hd__inv_1_55.A sky130_fd_sc_hd__nand2_1_2.A a_4537_3311# sky130_fd_sc_hd__nand2_1_59.VNB sky130_fd_pr__nfet_01v8 ad=0.169 pd=1.82 as=0.08775 ps=0.92 w=0.65 l=0.15
X519 sky130_fd_sc_hd__inv_1_138.A sky130_fd_sc_hd__inv_1_139.A vss sky130_fd_sc_hd__nand2_1_59.VNB sky130_fd_pr__nfet_01v8 ad=0.169 pd=1.82 as=0.169 ps=1.82 w=0.65 l=0.15
X520 sky130_fd_sc_hd__nand2_1_37.B sky130_fd_sc_hd__nand2_1_2.B vdd sky130_fd_sc_hd__nand2_1_36.VPB sky130_fd_pr__pfet_01v8_hvt ad=0.26 pd=2.52 as=0.26 ps=2.52 w=1 l=0.15
X521 a_1861_6351# sky130_fd_sc_hd__nand2_1_16.B vss sky130_fd_sc_hd__nand2_1_59.VNB sky130_fd_pr__nfet_01v8 ad=0.08775 pd=0.92 as=0.169 ps=1.82 w=0.65 l=0.15
X522 sky130_fd_sc_hd__inv_1_120.A sky130_fd_sc_hd__nand2_1_2.A vdd sky130_fd_sc_hd__nand2_1_44.VPB sky130_fd_pr__pfet_01v8_hvt ad=0.26 pd=2.52 as=0.26 ps=2.52 w=1 l=0.15
X523 vdd bit1_b bit1 sky130_fd_sc_hd__nand2_1_3.VPB sky130_fd_pr__pfet_01v8_hvt ad=0.26 pd=2.52 as=0.135 ps=1.27 w=1 l=0.15
X524 vdd sky130_fd_sc_hd__nand2_1_48.Y sky130_fd_sc_hd__nand2_1_2.B sky130_fd_sc_hd__nand2_1_44.VPB sky130_fd_pr__pfet_01v8_hvt ad=0.26 pd=2.52 as=0.135 ps=1.27 w=1 l=0.15
X525 sky130_fd_sc_hd__inv_1_59.A sky130_fd_sc_hd__inv_1_60.A vss sky130_fd_sc_hd__nand2_1_59.VNB sky130_fd_pr__nfet_01v8 ad=0.169 pd=1.82 as=0.169 ps=1.82 w=0.65 l=0.15
X526 a_2321_4175# sky130_fd_sc_hd__nand2_1_31.B vss sky130_fd_sc_hd__nand2_1_59.VNB sky130_fd_pr__nfet_01v8 ad=0.08775 pd=0.92 as=0.169 ps=1.82 w=0.65 l=0.15
X527 vdd sky130_fd_sc_hd__nand2_1_2.B a_3973_297# sky130_fd_sc_hd__nand2_1_52.VPB sky130_fd_pr__pfet_01v8_hvt ad=0.26 pd=2.52 as=0.105 ps=1.21 w=1 l=0.15
X528 sky130_fd_sc_hd__nand2_1_2.B sky130_fd_sc_hd__inv_1_118.A vdd sky130_fd_sc_hd__nand2_1_44.VPB sky130_fd_pr__pfet_01v8_hvt ad=0.26 pd=2.52 as=0.26 ps=2.52 w=1 l=0.15
X529 a_193_8527# outn a_109_8527# sky130_fd_sc_hd__nand2_1_59.VNB sky130_fd_pr__nfet_01v8 ad=0.10725 pd=0.98 as=0.08775 ps=0.92 w=0.65 l=0.15
X530 sky130_fd_sc_hd__inv_1_34.A sky130_fd_sc_hd__inv_1_35.A vdd sky130_fd_sc_hd__nand2_1_21.VPB sky130_fd_pr__pfet_01v8_hvt ad=0.26 pd=2.52 as=0.26 ps=2.52 w=1 l=0.15
X531 vdd sky130_fd_sc_hd__nand2_1_2.A sky130_fd_sc_hd__inv_1_0.A sky130_fd_sc_hd__nand2_1_0.VPB sky130_fd_pr__pfet_01v8_hvt ad=0.26 pd=2.52 as=0.135 ps=1.27 w=1 l=0.15
X532 a_3981_3561# sample sky130_fd_sc_hd__nand2_1_2.B sky130_fd_sc_hd__nand2_1_28.VPB sky130_fd_pr__pfet_01v8_hvt ad=0.105 pd=1.21 as=0.26 ps=2.52 w=1 l=0.15
X533 sky130_fd_sc_hd__nand2_1_2.B sample vdd sky130_fd_sc_hd__nand2_1_3.VPB sky130_fd_pr__pfet_01v8_hvt ad=0.26 pd=2.52 as=0.26 ps=2.52 w=1 l=0.15
X534 sky130_fd_sc_hd__inv_1_75.A sky130_fd_sc_hd__nand2_1_2.A vdd sky130_fd_sc_hd__nand2_1_36.VPB sky130_fd_pr__pfet_01v8_hvt ad=0.26 pd=2.52 as=0.26 ps=2.52 w=1 l=0.15
X535 bit0 bit0_b a_1861_8751# sky130_fd_sc_hd__nand2_1_59.VNB sky130_fd_pr__nfet_01v8 ad=0.169 pd=1.82 as=0.08775 ps=0.92 w=0.65 l=0.15
X536 sky130_fd_sc_hd__nand2_1_2.B sample vss sky130_fd_sc_hd__nand2_1_59.VNB sky130_fd_pr__nfet_01v8 ad=0.08775 pd=0.92 as=0.169 ps=1.82 w=0.65 l=0.15
X537 vdd sky130_fd_sc_hd__nand2_1_36.Y sky130_fd_sc_hd__nand2_1_2.B sky130_fd_sc_hd__nand2_1_36.VPB sky130_fd_pr__pfet_01v8_hvt ad=0.26 pd=2.52 as=0.135 ps=1.27 w=1 l=0.15
X538 vdd bit0 bit0_b sky130_fd_sc_hd__nand2_1_0.VPB sky130_fd_pr__pfet_01v8_hvt ad=0.26 pd=2.52 as=0.135 ps=1.27 w=1 l=0.15
X539 sky130_fd_sc_hd__nand2_1_13.B sky130_fd_sc_hd__nand2_1_2.B vss sky130_fd_sc_hd__nand2_1_59.VNB sky130_fd_pr__nfet_01v8 ad=0.169 pd=1.82 as=0.169 ps=1.82 w=0.65 l=0.15
X540 sky130_fd_sc_hd__nand2_1_27.B sky130_fd_sc_hd__inv_1_32.A vdd sky130_fd_sc_hd__nand2_1_21.VPB sky130_fd_pr__pfet_01v8_hvt ad=0.26 pd=2.52 as=0.26 ps=2.52 w=1 l=0.15
X541 sky130_fd_sc_hd__nand2_1_2.B sky130_fd_sc_hd__nand2_1_2.B vss sky130_fd_sc_hd__nand2_1_59.VNB sky130_fd_pr__nfet_01v8 ad=0.08775 pd=0.92 as=0.169 ps=1.82 w=0.65 l=0.15
X542 sky130_fd_sc_hd__inv_1_52.A sky130_fd_sc_hd__inv_1_53.A vss sky130_fd_sc_hd__nand2_1_59.VNB sky130_fd_pr__nfet_01v8 ad=0.169 pd=1.82 as=0.169 ps=1.82 w=0.65 l=0.15
X543 sky130_fd_sc_hd__inv_1_78.A sky130_fd_sc_hd__inv_1_79.A vss sky130_fd_sc_hd__nand2_1_59.VNB sky130_fd_pr__nfet_01v8 ad=0.169 pd=1.82 as=0.169 ps=1.82 w=0.65 l=0.15
X544 sky130_fd_sc_hd__inv_1_100.A sky130_fd_sc_hd__nand2_1_2.B vdd sky130_fd_sc_hd__nand2_1_44.VPB sky130_fd_pr__pfet_01v8_hvt ad=0.135 pd=1.27 as=0.26 ps=2.52 w=1 l=0.15
X545 sky130_fd_sc_hd__nand2_1_2.B sky130_fd_sc_hd__inv_1_73.A vdd sky130_fd_sc_hd__nand2_1_36.VPB sky130_fd_pr__pfet_01v8_hvt ad=0.26 pd=2.52 as=0.26 ps=2.52 w=1 l=0.15
X546 sky130_fd_sc_hd__inv_1_64.A sky130_fd_sc_hd__inv_1_65.A vdd sky130_fd_sc_hd__nand2_1_28.VPB sky130_fd_pr__pfet_01v8_hvt ad=0.26 pd=2.52 as=0.26 ps=2.52 w=1 l=0.15
X547 sky130_fd_sc_hd__nand2_1_2.A sky130_fd_sc_hd__nand2_1_2.B vdd sky130_fd_sc_hd__nand2_1_0.VPB sky130_fd_pr__pfet_01v8_hvt ad=0.135 pd=1.27 as=0.26 ps=2.52 w=1 l=0.15
X548 bit7_b sky130_fd_sc_hd__nand2_1_21.B vdd sky130_fd_sc_hd__nand2_1_21.VPB sky130_fd_pr__pfet_01v8_hvt ad=0.135 pd=1.27 as=0.26 ps=2.52 w=1 l=0.15
X549 sky130_fd_sc_hd__nand2_1_2.B sky130_fd_sc_hd__inv_1_133.A vdd sky130_fd_sc_hd__nand2_1_52.VPB sky130_fd_pr__pfet_01v8_hvt ad=0.26 pd=2.52 as=0.26 ps=2.52 w=1 l=0.15
X550 sky130_fd_sc_hd__inv_1_94.A sky130_fd_sc_hd__inv_1_95.A vss sky130_fd_sc_hd__nand2_1_59.VNB sky130_fd_pr__nfet_01v8 ad=0.169 pd=1.82 as=0.169 ps=1.82 w=0.65 l=0.15
X551 sky130_fd_sc_hd__nand2_1_40.B sky130_fd_sc_hd__inv_1_85.A vdd sky130_fd_sc_hd__nand2_1_36.VPB sky130_fd_pr__pfet_01v8_hvt ad=0.26 pd=2.52 as=0.26 ps=2.52 w=1 l=0.15
X552 sky130_fd_sc_hd__nand2_1_35.B sky130_fd_sc_hd__inv_1_62.A vdd sky130_fd_sc_hd__nand2_1_28.VPB sky130_fd_pr__pfet_01v8_hvt ad=0.26 pd=2.52 as=0.26 ps=2.52 w=1 l=0.15
X553 sky130_fd_sc_hd__inv_1_151.A sky130_fd_sc_hd__nand2_1_58.A vss sky130_fd_sc_hd__nand2_1_59.VNB sky130_fd_pr__nfet_01v8 ad=0.169 pd=1.82 as=0.169 ps=1.82 w=0.65 l=0.15
X554 sky130_fd_sc_hd__nand2_1_44.Y sky130_fd_sc_hd__nand2_1_44.B vdd sky130_fd_sc_hd__nand2_1_44.VPB sky130_fd_pr__pfet_01v8_hvt ad=0.135 pd=1.27 as=0.26 ps=2.52 w=1 l=0.15
X555 bit7 bit7_b a_1861_5263# sky130_fd_sc_hd__nand2_1_59.VNB sky130_fd_pr__nfet_01v8 ad=0.169 pd=1.82 as=0.08775 ps=0.92 w=0.65 l=0.15
X556 sky130_fd_sc_hd__nand2_1_2.B sky130_fd_sc_hd__nand2_1_2.B vss sky130_fd_sc_hd__nand2_1_59.VNB sky130_fd_pr__nfet_01v8 ad=0.08775 pd=0.92 as=0.169 ps=1.82 w=0.65 l=0.15
X557 sky130_fd_sc_hd__nand2_1_2.A sky130_fd_sc_hd__nand2_1_51.B vdd sky130_fd_sc_hd__nand2_1_44.VPB sky130_fd_pr__pfet_01v8_hvt ad=0.135 pd=1.27 as=0.26 ps=2.52 w=1 l=0.15
X558 sky130_fd_sc_hd__inv_1_68.A sky130_fd_sc_hd__nand2_1_2.B vss sky130_fd_sc_hd__nand2_1_59.VNB sky130_fd_pr__nfet_01v8 ad=0.169 pd=1.82 as=0.169 ps=1.82 w=0.65 l=0.15
X559 sky130_fd_sc_hd__inv_1_36.A sky130_fd_sc_hd__inv_1_37.A vss sky130_fd_sc_hd__nand2_1_59.VNB sky130_fd_pr__nfet_01v8 ad=0.169 pd=1.82 as=0.169 ps=1.82 w=0.65 l=0.15
X560 sky130_fd_sc_hd__nand2_1_48.B sky130_fd_sc_hd__inv_1_115.A vss sky130_fd_sc_hd__nand2_1_59.VNB sky130_fd_pr__nfet_01v8 ad=0.169 pd=1.82 as=0.169 ps=1.82 w=0.65 l=0.15
X561 sky130_fd_sc_hd__nand2_1_43.B sky130_fd_sc_hd__inv_1_92.A vss sky130_fd_sc_hd__nand2_1_59.VNB sky130_fd_pr__nfet_01v8 ad=0.169 pd=1.82 as=0.169 ps=1.82 w=0.65 l=0.15
X562 sky130_fd_sc_hd__nand2_1_2.A sky130_fd_sc_hd__nand2_1_2.A a_2321_3087# sky130_fd_sc_hd__nand2_1_59.VNB sky130_fd_pr__nfet_01v8 ad=0.169 pd=1.82 as=0.08775 ps=0.92 w=0.65 l=0.15
X563 a_1309_5487# sky130_fd_sc_hd__nand2_1_2.B vss sky130_fd_sc_hd__nand2_1_59.VNB sky130_fd_pr__nfet_01v8 ad=0.08775 pd=0.92 as=0.169 ps=1.82 w=0.65 l=0.15
X564 sky130_fd_sc_hd__nand2_1_2.B sky130_fd_sc_hd__nand2_1_2.B vss sky130_fd_sc_hd__nand2_1_59.VNB sky130_fd_pr__nfet_01v8 ad=0.169 pd=1.82 as=0.169 ps=1.82 w=0.65 l=0.15
X565 vdd outn sky130_fd_sc_hd__nand2_1_2.A sky130_fd_sc_hd__nand2_1_15.VPB sky130_fd_pr__pfet_01v8_hvt ad=0.165 pd=1.33 as=0.135 ps=1.27 w=1 l=0.15
X566 sky130_fd_sc_hd__inv_1_150.A sky130_fd_sc_hd__inv_1_151.A vss sky130_fd_sc_hd__nand2_1_59.VNB sky130_fd_pr__nfet_01v8 ad=0.169 pd=1.82 as=0.169 ps=1.82 w=0.65 l=0.15
X567 sky130_fd_sc_hd__nand2_1_9.B sky130_fd_sc_hd__inv_1_9.A vdd sky130_fd_sc_hd__nand2_1_9.VPB sky130_fd_pr__pfet_01v8_hvt ad=0.26 pd=2.52 as=0.26 ps=2.52 w=1 l=0.15
X568 sky130_fd_sc_hd__nand2_1_24.B sky130_fd_sc_hd__inv_1_24.A vss sky130_fd_sc_hd__nand2_1_59.VNB sky130_fd_pr__nfet_01v8 ad=0.169 pd=1.82 as=0.169 ps=1.82 w=0.65 l=0.15
X569 sky130_fd_sc_hd__nand2_1_28.B sky130_fd_sc_hd__inv_1_40.A vdd sky130_fd_sc_hd__nand2_1_28.VPB sky130_fd_pr__pfet_01v8_hvt ad=0.26 pd=2.52 as=0.26 ps=2.52 w=1 l=0.15
X570 bit7 sky130_fd_sc_hd__nand2_1_22.B vdd sky130_fd_sc_hd__nand2_1_21.VPB sky130_fd_pr__pfet_01v8_hvt ad=0.135 pd=1.27 as=0.26 ps=2.52 w=1 l=0.15
X571 sky130_fd_sc_hd__nand2_1_2.A sky130_fd_sc_hd__nand2_1_39.B vdd sky130_fd_sc_hd__nand2_1_36.VPB sky130_fd_pr__pfet_01v8_hvt ad=0.135 pd=1.27 as=0.26 ps=2.52 w=1 l=0.15
X572 sky130_fd_sc_hd__inv_1_43.A sky130_fd_sc_hd__inv_1_44.A vss sky130_fd_sc_hd__nand2_1_59.VNB sky130_fd_pr__nfet_01v8 ad=0.169 pd=1.82 as=0.169 ps=1.82 w=0.65 l=0.15
X573 sky130_fd_sc_hd__inv_1_3.A outn a_1309_8527# sky130_fd_sc_hd__nand2_1_59.VNB sky130_fd_pr__nfet_01v8 ad=0.169 pd=1.82 as=0.08775 ps=0.92 w=0.65 l=0.15
X574 sky130_fd_sc_hd__inv_1_127.A sky130_fd_sc_hd__inv_1_128.A vdd sky130_fd_sc_hd__nand2_1_44.VPB sky130_fd_pr__pfet_01v8_hvt ad=0.26 pd=2.52 as=0.26 ps=2.52 w=1 l=0.15
X575 sky130_fd_sc_hd__nand2_1_15.B sky130_fd_sc_hd__inv_1_15.A vdd sky130_fd_sc_hd__nand2_1_15.VPB sky130_fd_pr__pfet_01v8_hvt ad=0.26 pd=2.52 as=0.26 ps=2.52 w=1 l=0.15
X576 vss sky130_fd_sc_hd__nand2_1_2.B sky130_fd_sc_hd__nand2_1_2.B sky130_fd_sc_hd__nand2_1_59.VNB sky130_fd_pr__nfet_01v8 ad=0.169 pd=1.82 as=0.08775 ps=0.92 w=0.65 l=0.15
X577 sky130_fd_sc_hd__nand2_1_2.B sample vss sky130_fd_sc_hd__nand2_1_59.VNB sky130_fd_pr__nfet_01v8 ad=0.169 pd=1.82 as=0.169 ps=1.82 w=0.65 l=0.15
X578 a_5089_3087# sky130_fd_sc_hd__nand2_1_37.B vss sky130_fd_sc_hd__nand2_1_59.VNB sky130_fd_pr__nfet_01v8 ad=0.08775 pd=0.92 as=0.169 ps=1.82 w=0.65 l=0.15
X579 bit1_b bit1 a_2137_8527# sky130_fd_sc_hd__nand2_1_59.VNB sky130_fd_pr__nfet_01v8 ad=0.169 pd=1.82 as=0.08775 ps=0.92 w=0.65 l=0.15
X580 a_753_6825# sample sky130_fd_sc_hd__nand2_1_2.B sky130_fd_sc_hd__nand2_1_9.VPB sky130_fd_pr__pfet_01v8_hvt ad=0.105 pd=1.21 as=0.26 ps=2.52 w=1 l=0.15
X581 sky130_fd_sc_hd__inv_1_30.A sky130_fd_sc_hd__nand2_1_2.A vss sky130_fd_sc_hd__nand2_1_59.VNB sky130_fd_pr__nfet_01v8 ad=0.169 pd=1.82 as=0.169 ps=1.82 w=0.65 l=0.15
X582 vss sky130_fd_sc_hd__nand2_1_2.B sky130_fd_sc_hd__nand2_1_2.B sky130_fd_sc_hd__nand2_1_59.VNB sky130_fd_pr__nfet_01v8 ad=0.169 pd=1.82 as=0.08775 ps=0.92 w=0.65 l=0.15
X583 sky130_fd_sc_hd__nand2_1_6.B sky130_fd_sc_hd__inv_1_6.A vss sky130_fd_sc_hd__nand2_1_59.VNB sky130_fd_pr__nfet_01v8 ad=0.169 pd=1.82 as=0.169 ps=1.82 w=0.65 l=0.15
X584 a_109_8527# sky130_fd_sc_hd__nand2_1_2.B vss sky130_fd_sc_hd__nand2_1_59.VNB sky130_fd_pr__nfet_01v8 ad=0.08775 pd=0.92 as=0.169 ps=1.82 w=0.65 l=0.15
X585 sky130_fd_sc_hd__inv_1_40.A sky130_fd_sc_hd__nand2_1_2.A a_4537_4175# sky130_fd_sc_hd__nand2_1_59.VNB sky130_fd_pr__nfet_01v8 ad=0.169 pd=1.82 as=0.08775 ps=0.92 w=0.65 l=0.15
X586 sky130_fd_sc_hd__inv_1_6.A sky130_fd_sc_hd__nand2_1_2.B vdd sky130_fd_sc_hd__nand2_1_3.VPB sky130_fd_pr__pfet_01v8_hvt ad=0.135 pd=1.27 as=0.26 ps=2.52 w=1 l=0.15
X587 sky130_fd_sc_hd__inv_1_27.A sky130_fd_sc_hd__inv_1_28.A vss sky130_fd_sc_hd__nand2_1_59.VNB sky130_fd_pr__nfet_01v8 ad=0.169 pd=1.82 as=0.169 ps=1.82 w=0.65 l=0.15
X588 vdd sky130_fd_sc_hd__nand2_1_2.A sky130_fd_sc_hd__nand2_1_2.A sky130_fd_sc_hd__nand2_1_52.VPB sky130_fd_pr__pfet_01v8_hvt ad=0.26 pd=2.52 as=0.135 ps=1.27 w=1 l=0.15
X589 vdd sky130_fd_sc_hd__nand2_1_2.B a_753_9001# sky130_fd_sc_hd__nand2_1_0.VPB sky130_fd_pr__pfet_01v8_hvt ad=0.26 pd=2.52 as=0.105 ps=1.21 w=1 l=0.15
X590 sky130_fd_sc_hd__inv_1_139.A sky130_fd_sc_hd__inv_1_140.A vss sky130_fd_sc_hd__nand2_1_59.VNB sky130_fd_pr__nfet_01v8 ad=0.169 pd=1.82 as=0.169 ps=1.82 w=0.65 l=0.15
X591 sky130_fd_sc_hd__nand2_1_44.B sky130_fd_sc_hd__inv_1_100.A vss sky130_fd_sc_hd__nand2_1_59.VNB sky130_fd_pr__nfet_01v8 ad=0.169 pd=1.82 as=0.169 ps=1.82 w=0.65 l=0.15
X592 sky130_fd_sc_hd__inv_1_82.A sky130_fd_sc_hd__inv_1_83.A vdd sky130_fd_sc_hd__nand2_1_36.VPB sky130_fd_pr__pfet_01v8_hvt ad=0.26 pd=2.52 as=0.26 ps=2.52 w=1 l=0.15
X593 sky130_fd_sc_hd__inv_1_108.A sky130_fd_sc_hd__inv_1_109.A vdd sky130_fd_sc_hd__nand2_1_44.VPB sky130_fd_pr__pfet_01v8_hvt ad=0.26 pd=2.52 as=0.26 ps=2.52 w=1 l=0.15
X594 a_2137_6575# sky130_fd_sc_hd__nand2_1_12.B vss sky130_fd_sc_hd__nand2_1_59.VNB sky130_fd_pr__nfet_01v8 ad=0.08775 pd=0.92 as=0.169 ps=1.82 w=0.65 l=0.15
X595 vss sky130_fd_sc_hd__nand2_1_2.B sky130_fd_sc_hd__inv_1_25.A sky130_fd_sc_hd__nand2_1_59.VNB sky130_fd_pr__nfet_01v8 ad=0.169 pd=1.82 as=0.08775 ps=0.92 w=0.65 l=0.15
X596 sky130_fd_sc_hd__inv_1_44.A sky130_fd_sc_hd__inv_1_45.A vss sky130_fd_sc_hd__nand2_1_59.VNB sky130_fd_pr__nfet_01v8 ad=0.169 pd=1.82 as=0.169 ps=1.82 w=0.65 l=0.15
X597 sky130_fd_sc_hd__inv_1_62.A sky130_fd_sc_hd__inv_1_63.A vss sky130_fd_sc_hd__nand2_1_59.VNB sky130_fd_pr__nfet_01v8 ad=0.169 pd=1.82 as=0.169 ps=1.82 w=0.65 l=0.15
X598 sky130_fd_sc_hd__inv_1_140.A sky130_fd_sc_hd__inv_1_141.A vss sky130_fd_sc_hd__nand2_1_59.VNB sky130_fd_pr__nfet_01v8 ad=0.169 pd=1.82 as=0.169 ps=1.82 w=0.65 l=0.15
X599 sky130_fd_sc_hd__nand2_1_1.B sky130_fd_sc_hd__nand2_1_2.B vdd sky130_fd_sc_hd__nand2_1_0.VPB sky130_fd_pr__pfet_01v8_hvt ad=0.26 pd=2.52 as=0.26 ps=2.52 w=1 l=0.15
X600 sky130_fd_sc_hd__nand2_1_2.A sky130_fd_sc_hd__nand2_1_2.A a_193_5487# sky130_fd_sc_hd__nand2_1_59.VNB sky130_fd_pr__nfet_01v8 ad=0.169 pd=1.82 as=0.10725 ps=0.98 w=0.65 l=0.15
X601 vdd sky130_fd_sc_hd__nand2_1_2.A sky130_fd_sc_hd__inv_1_18.A sky130_fd_sc_hd__nand2_1_15.VPB sky130_fd_pr__pfet_01v8_hvt ad=0.26 pd=2.52 as=0.135 ps=1.27 w=1 l=0.15
X602 sky130_fd_sc_hd__inv_1_118.A sky130_fd_sc_hd__inv_1_119.A vdd sky130_fd_sc_hd__nand2_1_44.VPB sky130_fd_pr__pfet_01v8_hvt ad=0.26 pd=2.52 as=0.26 ps=2.52 w=1 l=0.15
X603 a_4249_297# sky130_fd_sc_hd__nand2_1_2.B sky130_fd_sc_hd__nand2_1_2.B sky130_fd_sc_hd__nand2_1_52.VPB sky130_fd_pr__pfet_01v8_hvt ad=0.105 pd=1.21 as=0.26 ps=2.52 w=1 l=0.15
X604 vdd sky130_fd_sc_hd__nand2_1_2.A sky130_fd_sc_hd__nand2_1_2.A sky130_fd_sc_hd__nand2_1_44.VPB sky130_fd_pr__pfet_01v8_hvt ad=0.26 pd=2.52 as=0.135 ps=1.27 w=1 l=0.15
X605 sky130_fd_sc_hd__nand2_1_2.B sky130_fd_sc_hd__nand2_1_58.A a_3149_47# sky130_fd_sc_hd__nand2_1_59.VNB sky130_fd_pr__nfet_01v8 ad=0.169 pd=1.82 as=0.08775 ps=0.92 w=0.65 l=0.15
X606 sky130_fd_sc_hd__nand2_1_2.B sample vss sky130_fd_sc_hd__nand2_1_59.VNB sky130_fd_pr__nfet_01v8 ad=0.08775 pd=0.92 as=0.169 ps=1.82 w=0.65 l=0.15
X607 sky130_fd_sc_hd__nand2_1_2.B sample vss sky130_fd_sc_hd__nand2_1_59.VNB sky130_fd_pr__nfet_01v8 ad=0.169 pd=1.82 as=0.169 ps=1.82 w=0.65 l=0.15
X608 a_1861_6575# sky130_fd_sc_hd__nand2_1_13.B vss sky130_fd_sc_hd__nand2_1_59.VNB sky130_fd_pr__nfet_01v8 ad=0.08775 pd=0.92 as=0.169 ps=1.82 w=0.65 l=0.15
X609 vdd bit6 bit6_b sky130_fd_sc_hd__nand2_1_15.VPB sky130_fd_pr__pfet_01v8_hvt ad=0.26 pd=2.52 as=0.135 ps=1.27 w=1 l=0.15
X610 sky130_fd_sc_hd__nand2_1_58.A sample vss sky130_fd_sc_hd__nand2_1_59.VNB sky130_fd_pr__nfet_01v8 ad=0.169 pd=1.82 as=0.169 ps=1.82 w=0.65 l=0.15
X611 a_2321_4399# sky130_fd_sc_hd__nand2_1_27.B vss sky130_fd_sc_hd__nand2_1_59.VNB sky130_fd_pr__nfet_01v8 ad=0.08775 pd=0.92 as=0.169 ps=1.82 w=0.65 l=0.15
X612 sky130_fd_sc_hd__nand2_1_2.A sky130_fd_sc_hd__nand2_1_2.B vdd sky130_fd_sc_hd__nand2_1_15.VPB sky130_fd_pr__pfet_01v8_hvt ad=0.135 pd=1.27 as=0.26 ps=2.52 w=1 l=0.15
X613 vdd outn outn sky130_fd_sc_hd__nand2_1_9.VPB sky130_fd_pr__pfet_01v8_hvt ad=0.165 pd=1.33 as=0.135 ps=1.27 w=1 l=0.15
X614 vdd sky130_fd_sc_hd__nand2_1_2.A sky130_fd_sc_hd__inv_1_115.A sky130_fd_sc_hd__nand2_1_44.VPB sky130_fd_pr__pfet_01v8_hvt ad=0.26 pd=2.52 as=0.135 ps=1.27 w=1 l=0.15
X615 sky130_fd_sc_hd__inv_1_79.A sky130_fd_sc_hd__inv_1_80.A vss sky130_fd_sc_hd__nand2_1_59.VNB sky130_fd_pr__nfet_01v8 ad=0.169 pd=1.82 as=0.169 ps=1.82 w=0.65 l=0.15
X616 sky130_fd_sc_hd__inv_1_133.A sky130_fd_sc_hd__inv_1_134.A vdd sky130_fd_sc_hd__nand2_1_52.VPB sky130_fd_pr__pfet_01v8_hvt ad=0.26 pd=2.52 as=0.26 ps=2.52 w=1 l=0.15
X617 sky130_fd_sc_hd__nand2_1_2.B sample vdd sky130_fd_sc_hd__nand2_1_36.VPB sky130_fd_pr__pfet_01v8_hvt ad=0.26 pd=2.52 as=0.26 ps=2.52 w=1 l=0.15
X618 sky130_fd_sc_hd__nand2_1_2.B sample vss sky130_fd_sc_hd__nand2_1_59.VNB sky130_fd_pr__nfet_01v8 ad=0.169 pd=1.82 as=0.169 ps=1.82 w=0.65 l=0.15
X619 sky130_fd_sc_hd__inv_1_73.A sky130_fd_sc_hd__inv_1_74.A vdd sky130_fd_sc_hd__nand2_1_36.VPB sky130_fd_pr__pfet_01v8_hvt ad=0.26 pd=2.52 as=0.26 ps=2.52 w=1 l=0.15
X620 sky130_fd_sc_hd__inv_1_130.A sky130_fd_sc_hd__nand2_1_2.A a_4537_911# sky130_fd_sc_hd__nand2_1_59.VNB sky130_fd_pr__nfet_01v8 ad=0.169 pd=1.82 as=0.08775 ps=0.92 w=0.65 l=0.15
X621 sky130_fd_sc_hd__inv_1_53.A sky130_fd_sc_hd__nand2_1_2.B vss sky130_fd_sc_hd__nand2_1_59.VNB sky130_fd_pr__nfet_01v8 ad=0.169 pd=1.82 as=0.169 ps=1.82 w=0.65 l=0.15
X622 sky130_fd_sc_hd__inv_1_119.A sky130_fd_sc_hd__inv_1_120.A vdd sky130_fd_sc_hd__nand2_1_44.VPB sky130_fd_pr__pfet_01v8_hvt ad=0.26 pd=2.52 as=0.26 ps=2.52 w=1 l=0.15
X623 sky130_fd_sc_hd__nand2_1_2.B sample vss sky130_fd_sc_hd__nand2_1_59.VNB sky130_fd_pr__nfet_01v8 ad=0.169 pd=1.82 as=0.169 ps=1.82 w=0.65 l=0.15
X624 sky130_fd_sc_hd__nand2_1_39.B sky130_fd_sc_hd__inv_1_77.A vss sky130_fd_sc_hd__nand2_1_59.VNB sky130_fd_pr__nfet_01v8 ad=0.169 pd=1.82 as=0.169 ps=1.82 w=0.65 l=0.15
X625 vdd outn sky130_fd_sc_hd__nand2_1_2.B sky130_fd_sc_hd__nand2_1_15.VPB sky130_fd_pr__pfet_01v8_hvt ad=0.165 pd=1.33 as=0.135 ps=1.27 w=1 l=0.15
X626 sky130_fd_sc_hd__nand2_1_2.A sky130_fd_sc_hd__nand2_1_2.A vdd sky130_fd_sc_hd__nand2_1_3.VPB sky130_fd_pr__pfet_01v8_hvt ad=0.26 pd=2.52 as=0.165 ps=1.33 w=1 l=0.15
X627 sky130_fd_sc_hd__nand2_1_2.B sky130_fd_sc_hd__nand2_1_45.B vdd sky130_fd_sc_hd__nand2_1_44.VPB sky130_fd_pr__pfet_01v8_hvt ad=0.135 pd=1.27 as=0.26 ps=2.52 w=1 l=0.15
X628 sky130_fd_sc_hd__inv_1_35.A sky130_fd_sc_hd__inv_1_36.A vdd sky130_fd_sc_hd__nand2_1_21.VPB sky130_fd_pr__pfet_01v8_hvt ad=0.26 pd=2.52 as=0.26 ps=2.52 w=1 l=0.15
X629 a_4537_3311# sky130_fd_sc_hd__nand2_1_2.B vss sky130_fd_sc_hd__nand2_1_59.VNB sky130_fd_pr__nfet_01v8 ad=0.08775 pd=0.92 as=0.169 ps=1.82 w=0.65 l=0.15
X630 a_753_8207# sample sky130_fd_sc_hd__nand2_1_2.B sky130_fd_sc_hd__nand2_1_3.VPB sky130_fd_pr__pfet_01v8_hvt ad=0.105 pd=1.21 as=0.26 ps=2.52 w=1 l=0.15
X631 sky130_fd_sc_hd__inv_1_37.A sky130_fd_sc_hd__inv_1_38.A vss sky130_fd_sc_hd__nand2_1_59.VNB sky130_fd_pr__nfet_01v8 ad=0.169 pd=1.82 as=0.169 ps=1.82 w=0.65 l=0.15
X632 a_193_7663# outn a_109_7663# sky130_fd_sc_hd__nand2_1_59.VNB sky130_fd_pr__nfet_01v8 ad=0.10725 pd=0.98 as=0.08775 ps=0.92 w=0.65 l=0.15
X633 sky130_fd_sc_hd__inv_1_130.A sky130_fd_sc_hd__nand2_1_2.B vdd sky130_fd_sc_hd__nand2_1_52.VPB sky130_fd_pr__pfet_01v8_hvt ad=0.135 pd=1.27 as=0.26 ps=2.52 w=1 l=0.15
X634 vdd sky130_fd_sc_hd__nand2_1_2.A sky130_fd_sc_hd__inv_1_70.A sky130_fd_sc_hd__nand2_1_36.VPB sky130_fd_pr__pfet_01v8_hvt ad=0.26 pd=2.52 as=0.135 ps=1.27 w=1 l=0.15
X635 a_5365_3311# sky130_fd_sc_hd__nand2_1_32.B vss sky130_fd_sc_hd__nand2_1_59.VNB sky130_fd_pr__nfet_01v8 ad=0.08775 pd=0.92 as=0.169 ps=1.82 w=0.65 l=0.15
X636 sky130_fd_sc_hd__nand2_1_2.B sample vdd sky130_fd_sc_hd__nand2_1_28.VPB sky130_fd_pr__pfet_01v8_hvt ad=0.26 pd=2.52 as=0.26 ps=2.52 w=1 l=0.15
X637 sky130_fd_sc_hd__nand2_1_4.B sky130_fd_sc_hd__nand2_1_2.B vss sky130_fd_sc_hd__nand2_1_59.VNB sky130_fd_pr__nfet_01v8 ad=0.169 pd=1.82 as=0.169 ps=1.82 w=0.65 l=0.15
X638 sky130_fd_sc_hd__nand2_1_2.A sky130_fd_sc_hd__nand2_1_55.B vdd sky130_fd_sc_hd__nand2_1_52.VPB sky130_fd_pr__pfet_01v8_hvt ad=0.135 pd=1.27 as=0.26 ps=2.52 w=1 l=0.15
X639 sky130_fd_sc_hd__inv_1_135.A sky130_fd_sc_hd__nand2_1_2.A vss sky130_fd_sc_hd__nand2_1_59.VNB sky130_fd_pr__nfet_01v8 ad=0.169 pd=1.82 as=0.169 ps=1.82 w=0.65 l=0.15
X640 sky130_fd_sc_hd__inv_1_74.A sky130_fd_sc_hd__inv_1_75.A vdd sky130_fd_sc_hd__nand2_1_36.VPB sky130_fd_pr__pfet_01v8_hvt ad=0.26 pd=2.52 as=0.26 ps=2.52 w=1 l=0.15
X641 sky130_fd_sc_hd__inv_1_65.A sky130_fd_sc_hd__inv_1_66.A vdd sky130_fd_sc_hd__nand2_1_28.VPB sky130_fd_pr__pfet_01v8_hvt ad=0.26 pd=2.52 as=0.26 ps=2.52 w=1 l=0.15
X642 sky130_fd_sc_hd__inv_1_141.A sky130_fd_sc_hd__inv_1_142.A vss sky130_fd_sc_hd__nand2_1_59.VNB sky130_fd_pr__nfet_01v8 ad=0.169 pd=1.82 as=0.169 ps=1.82 w=0.65 l=0.15
X643 bit6 bit6_b a_1861_5487# sky130_fd_sc_hd__nand2_1_59.VNB sky130_fd_pr__nfet_01v8 ad=0.169 pd=1.82 as=0.08775 ps=0.92 w=0.65 l=0.15
X644 sky130_fd_sc_hd__inv_1_95.A sky130_fd_sc_hd__inv_1_96.A vss sky130_fd_sc_hd__nand2_1_59.VNB sky130_fd_pr__nfet_01v8 ad=0.169 pd=1.82 as=0.169 ps=1.82 w=0.65 l=0.15
X645 vdd sky130_fd_sc_hd__nand2_1_2.B a_5077_297# sky130_fd_sc_hd__nand2_1_52.VPB sky130_fd_pr__pfet_01v8_hvt ad=0.26 pd=2.52 as=0.105 ps=1.21 w=1 l=0.15
X646 sky130_fd_sc_hd__nand2_1_2.B sample vss sky130_fd_sc_hd__nand2_1_59.VNB sky130_fd_pr__nfet_01v8 ad=0.08775 pd=0.92 as=0.169 ps=1.82 w=0.65 l=0.15
X647 bit0_b sky130_fd_sc_hd__nand2_1_0.B vdd sky130_fd_sc_hd__nand2_1_0.VPB sky130_fd_pr__pfet_01v8_hvt ad=0.135 pd=1.27 as=0.26 ps=2.52 w=1 l=0.15
X648 vdd sky130_fd_sc_hd__nand2_1_24.Y sky130_fd_sc_hd__nand2_1_2.B sky130_fd_sc_hd__nand2_1_21.VPB sky130_fd_pr__pfet_01v8_hvt ad=0.26 pd=2.52 as=0.135 ps=1.27 w=1 l=0.15
X649 sky130_fd_sc_hd__inv_1_128.A sky130_fd_sc_hd__nand2_1_2.B vdd sky130_fd_sc_hd__nand2_1_44.VPB sky130_fd_pr__pfet_01v8_hvt ad=0.26 pd=2.52 as=0.26 ps=2.52 w=1 l=0.15
X650 vdd outn sky130_fd_sc_hd__inv_1_9.A sky130_fd_sc_hd__nand2_1_9.VPB sky130_fd_pr__pfet_01v8_hvt ad=0.26 pd=2.52 as=0.135 ps=1.27 w=1 l=0.15
X651 a_3981_1679# sample sky130_fd_sc_hd__nand2_1_2.B sky130_fd_sc_hd__nand2_1_44.VPB sky130_fd_pr__pfet_01v8_hvt ad=0.105 pd=1.21 as=0.26 ps=2.52 w=1 l=0.15
X652 vdd sky130_fd_sc_hd__nand2_1_2.B a_753_5737# sky130_fd_sc_hd__nand2_1_15.VPB sky130_fd_pr__pfet_01v8_hvt ad=0.26 pd=2.52 as=0.105 ps=1.21 w=1 l=0.15
X653 sky130_fd_sc_hd__nand2_1_2.B sample vss sky130_fd_sc_hd__nand2_1_59.VNB sky130_fd_pr__nfet_01v8 ad=0.169 pd=1.82 as=0.169 ps=1.82 w=0.65 l=0.15
X654 done sky130_fd_sc_hd__inv_1_27.A vdd sky130_fd_sc_hd__nand2_1_21.VPB sky130_fd_pr__pfet_01v8_hvt ad=0.26 pd=2.52 as=0.26 ps=2.52 w=1 l=0.15
X655 a_1309_7439# sky130_fd_sc_hd__nand2_1_2.B vss sky130_fd_sc_hd__nand2_1_59.VNB sky130_fd_pr__nfet_01v8 ad=0.08775 pd=0.92 as=0.169 ps=1.82 w=0.65 l=0.15
X656 vdd bit3 bit3_b sky130_fd_sc_hd__nand2_1_9.VPB sky130_fd_pr__pfet_01v8_hvt ad=0.26 pd=2.52 as=0.135 ps=1.27 w=1 l=0.15
X657 sky130_fd_sc_hd__inv_1_47.A sky130_fd_sc_hd__inv_1_48.A vss sky130_fd_sc_hd__nand2_1_59.VNB sky130_fd_pr__nfet_01v8 ad=0.169 pd=1.82 as=0.169 ps=1.82 w=0.65 l=0.15
X658 sky130_fd_sc_hd__inv_1_28.A sky130_fd_sc_hd__inv_1_29.A vss sky130_fd_sc_hd__nand2_1_59.VNB sky130_fd_pr__nfet_01v8 ad=0.169 pd=1.82 as=0.169 ps=1.82 w=0.65 l=0.15
X659 sky130_fd_sc_hd__nand2_1_2.B sample vss sky130_fd_sc_hd__nand2_1_59.VNB sky130_fd_pr__nfet_01v8 ad=0.08775 pd=0.92 as=0.169 ps=1.82 w=0.65 l=0.15
X660 vdd sky130_fd_sc_hd__nand2_1_2.B sky130_fd_sc_hd__nand2_1_32.Y sky130_fd_sc_hd__nand2_1_28.VPB sky130_fd_pr__pfet_01v8_hvt ad=0.26 pd=2.52 as=0.135 ps=1.27 w=1 l=0.15
X661 vdd sky130_fd_sc_hd__nand2_1_2.B sky130_fd_sc_hd__inv_1_15.A sky130_fd_sc_hd__nand2_1_15.VPB sky130_fd_pr__pfet_01v8_hvt ad=0.26 pd=2.52 as=0.135 ps=1.27 w=1 l=0.15
X662 sky130_fd_sc_hd__inv_1_109.A sky130_fd_sc_hd__inv_1_110.A vdd sky130_fd_sc_hd__nand2_1_44.VPB sky130_fd_pr__pfet_01v8_hvt ad=0.26 pd=2.52 as=0.26 ps=2.52 w=1 l=0.15
X663 outn sky130_fd_sc_hd__nand2_1_2.B vdd sky130_fd_sc_hd__nand2_1_9.VPB sky130_fd_pr__pfet_01v8_hvt ad=0.135 pd=1.27 as=0.26 ps=2.52 w=1 l=0.15
X664 sky130_fd_sc_hd__nand2_1_2.B sample vdd sky130_fd_sc_hd__nand2_1_21.VPB sky130_fd_pr__pfet_01v8_hvt ad=0.26 pd=2.52 as=0.26 ps=2.52 w=1 l=0.15
X665 sky130_fd_sc_hd__nand2_1_40.Y sky130_fd_sc_hd__nand2_1_2.B a_5365_2223# sky130_fd_sc_hd__nand2_1_59.VNB sky130_fd_pr__nfet_01v8 ad=0.169 pd=1.82 as=0.08775 ps=0.92 w=0.65 l=0.15
X666 vdd bit2_b bit2 sky130_fd_sc_hd__nand2_1_3.VPB sky130_fd_pr__pfet_01v8_hvt ad=0.26 pd=2.52 as=0.135 ps=1.27 w=1 l=0.15
X667 sky130_fd_sc_hd__inv_1_83.A sky130_fd_sc_hd__nand2_1_2.B vdd sky130_fd_sc_hd__nand2_1_36.VPB sky130_fd_pr__pfet_01v8_hvt ad=0.26 pd=2.52 as=0.26 ps=2.52 w=1 l=0.15
X668 bit0 sky130_fd_sc_hd__nand2_1_1.B vdd sky130_fd_sc_hd__nand2_1_0.VPB sky130_fd_pr__pfet_01v8_hvt ad=0.135 pd=1.27 as=0.26 ps=2.52 w=1 l=0.15
X669 a_1309_6351# sky130_fd_sc_hd__nand2_1_2.B vss sky130_fd_sc_hd__nand2_1_59.VNB sky130_fd_pr__nfet_01v8 ad=0.08775 pd=0.92 as=0.169 ps=1.82 w=0.65 l=0.15
X670 sky130_fd_sc_hd__nand2_1_19.B sky130_fd_sc_hd__nand2_1_2.B vdd sky130_fd_sc_hd__nand2_1_15.VPB sky130_fd_pr__pfet_01v8_hvt ad=0.26 pd=2.52 as=0.26 ps=2.52 w=1 l=0.15
X671 sky130_fd_sc_hd__nand2_1_2.B sample vss sky130_fd_sc_hd__nand2_1_59.VNB sky130_fd_pr__nfet_01v8 ad=0.08775 pd=0.92 as=0.169 ps=1.82 w=0.65 l=0.15
X672 sky130_fd_sc_hd__inv_1_6.A sky130_fd_sc_hd__nand2_1_2.A a_1309_7663# sky130_fd_sc_hd__nand2_1_59.VNB sky130_fd_pr__nfet_01v8 ad=0.169 pd=1.82 as=0.08775 ps=0.92 w=0.65 l=0.15
X673 vdd bit5 bit5_b sky130_fd_sc_hd__nand2_1_15.VPB sky130_fd_pr__pfet_01v8_hvt ad=0.26 pd=2.52 as=0.135 ps=1.27 w=1 l=0.15
X674 sky130_fd_sc_hd__nand2_1_47.B sky130_fd_sc_hd__inv_1_107.A vdd sky130_fd_sc_hd__nand2_1_44.VPB sky130_fd_pr__pfet_01v8_hvt ad=0.26 pd=2.52 as=0.26 ps=2.52 w=1 l=0.15
X675 sky130_fd_sc_hd__inv_1_63.A sky130_fd_sc_hd__inv_1_64.A vss sky130_fd_sc_hd__nand2_1_59.VNB sky130_fd_pr__nfet_01v8 ad=0.169 pd=1.82 as=0.169 ps=1.82 w=0.65 l=0.15
X676 vdd sky130_fd_sc_hd__nand2_1_2.B a_3981_2473# sky130_fd_sc_hd__nand2_1_36.VPB sky130_fd_pr__pfet_01v8_hvt ad=0.26 pd=2.52 as=0.105 ps=1.21 w=1 l=0.15
X677 sky130_fd_sc_hd__nand2_1_2.B sky130_fd_sc_hd__nand2_1_2.B vdd sky130_fd_sc_hd__nand2_1_15.VPB sky130_fd_pr__pfet_01v8_hvt ad=0.135 pd=1.27 as=0.26 ps=2.52 w=1 l=0.15
X678 bit2_b bit2 a_2137_7663# sky130_fd_sc_hd__nand2_1_59.VNB sky130_fd_pr__nfet_01v8 ad=0.169 pd=1.82 as=0.08775 ps=0.92 w=0.65 l=0.15
X679 vss sky130_fd_sc_hd__nand2_1_2.B sky130_fd_sc_hd__nand2_1_2.B sky130_fd_sc_hd__nand2_1_59.VNB sky130_fd_pr__nfet_01v8 ad=0.169 pd=1.82 as=0.08775 ps=0.92 w=0.65 l=0.15
X680 sky130_fd_sc_hd__inv_1_29.A sky130_fd_sc_hd__inv_1_30.A vss sky130_fd_sc_hd__nand2_1_59.VNB sky130_fd_pr__nfet_01v8 ad=0.169 pd=1.82 as=0.169 ps=1.82 w=0.65 l=0.15
X681 sky130_fd_sc_hd__inv_1_143.A sky130_fd_sc_hd__nand2_1_2.B vdd sky130_fd_sc_hd__nand2_1_52.VPB sky130_fd_pr__pfet_01v8_hvt ad=0.26 pd=2.52 as=0.26 ps=2.52 w=1 l=0.15
X682 a_109_7663# sky130_fd_sc_hd__nand2_1_2.B vss sky130_fd_sc_hd__nand2_1_59.VNB sky130_fd_pr__nfet_01v8 ad=0.08775 pd=0.92 as=0.169 ps=1.82 w=0.65 l=0.15
X683 sky130_fd_sc_hd__nand2_1_2.A sky130_fd_sc_hd__nand2_1_2.A a_2321_3311# sky130_fd_sc_hd__nand2_1_59.VNB sky130_fd_pr__nfet_01v8 ad=0.169 pd=1.82 as=0.08775 ps=0.92 w=0.65 l=0.15
.ends
