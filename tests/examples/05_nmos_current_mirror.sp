* NMOS Current Mirror
V1 vdd 0 3.3
I1 vdd diode 100u
M1 diode diode 0 0 nch W=10u L=2u
M2 out diode 0 0 nch W=10u L=2u
M3 out2 diode 0 0 nch W=20u L=2u
R1 vdd out 10k
R2 vdd out2 10k
